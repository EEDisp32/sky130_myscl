* NGSPICE file created from ALU.ext - technology: sky130A

.subckt inverter VGND VNB VPB VPWR Y A
X0 Y A VGND VNB sky130_fd_pr__nfet_01v8 ad=0.162 pd=1.65 as=0.162 ps=1.65 w=0.5 l=0.15
X1 Y A VPWR VPB sky130_fd_pr__pfet_01v8 ad=0.275 pd=2.34 as=0.275 ps=2.34 w=0.845 l=0.15
.ends

* Black-box entry subcircuit for sky130_fd_sc_hd__tapvpwrvgnd_1 abstract view
.subckt sky130_fd_sc_hd__tapvpwrvgnd_1 VGND VPWR
.ends

.subckt Xnor VPWR VGND VNB VPB A Y B
X0 a_109_47# A VGND VNB sky130_fd_pr__special_nfet_01v8 ad=0.0702 pd=0.75 as=0.0936 ps=1.24 w=0.36 l=0.15
X1 a_187_21# B VGND VNB sky130_fd_pr__special_nfet_01v8 ad=0.156 pd=1.59 as=0.0603 ps=0.695 w=0.36 l=0.15
X2 a_356_47# B Y VNB sky130_fd_pr__nfet_01v8 ad=0.162 pd=1.35 as=0.139 ps=1.2 w=0.65 l=0.15
X3 VGND a_109_47# a_356_47# VNB sky130_fd_pr__special_nfet_01v8 ad=0.0603 pd=0.695 as=0.162 ps=1.35 w=0.36 l=0.15
X4 VPWR a_109_47# a_372_413# VPB sky130_fd_pr__pfet_01v8 ad=0.237 pd=1.48 as=0.209 ps=1.65 w=1 l=0.15
X5 Y B a_109_47# VPB sky130_fd_pr__pfet_01v8 ad=0.286 pd=1.62 as=0.195 ps=1.39 w=1 l=0.15
X6 a_372_413# a_187_21# Y VPB sky130_fd_pr__pfet_01v8 ad=0.209 pd=1.65 as=0.286 ps=1.62 w=0.42 l=0.15
X7 a_187_21# B VPWR VPB sky130_fd_pr__pfet_01v8 ad=0.26 pd=2.52 as=0.237 ps=1.48 w=1 l=0.15
X8 Y a_187_21# a_109_47# VNB sky130_fd_pr__special_nfet_01v8 ad=0.139 pd=1.2 as=0.0702 ps=0.75 w=0.36 l=0.15
X9 a_109_47# A VPWR VPB sky130_fd_pr__pfet_01v8 ad=0.195 pd=1.39 as=0.26 ps=2.52 w=1 l=0.15
.ends

.subckt Nor_gate VGND VNB VPB VPWR A B Y
X0 a_110_297# A VPWR VPB sky130_fd_pr__pfet_01v8 ad=0.14 pd=1.28 as=0.265 ps=2.53 w=1 l=0.15
X1 VGND B Y VNB sky130_fd_pr__nfet_01v8 ad=0.167 pd=1.79 as=0.0882 ps=0.91 w=0.63 l=0.15
X2 Y A VGND VNB sky130_fd_pr__nfet_01v8 ad=0.0882 pd=0.91 as=0.167 ps=1.79 w=0.63 l=0.15
X3 Y B a_110_297# VPB sky130_fd_pr__pfet_01v8 ad=0.265 pd=2.53 as=0.14 ps=1.28 w=1 l=0.15
.ends

.subckt Nand_gate VGND VNB VPB VPWR A Y B
X0 Y A VPWR VPB sky130_fd_pr__pfet_01v8 ad=0.14 pd=1.28 as=0.265 ps=2.53 w=1 l=0.15
X1 Y B a_110_47# VNB sky130_fd_pr__nfet_01v8 ad=0.167 pd=1.79 as=0.0882 ps=0.91 w=0.63 l=0.15
X2 a_110_47# A VGND VNB sky130_fd_pr__nfet_01v8 ad=0.0882 pd=0.91 as=0.167 ps=1.79 w=0.63 l=0.15
X3 VPWR B Y VPB sky130_fd_pr__pfet_01v8 ad=0.265 pd=2.53 as=0.14 ps=1.28 w=1 l=0.15
.ends

* Black-box entry subcircuit for sky130_fd_sc_hd__fill_1 abstract view
.subckt sky130_fd_sc_hd__fill_1 VGND VNB VPB VPWR
.ends

* Black-box entry subcircuit for sky130_fd_sc_hd__decap_3 abstract view
.subckt sky130_fd_sc_hd__decap_3 VGND VNB VPB VPWR
.ends

* Black-box entry subcircuit for sky130_fd_sc_hd__decap_6 abstract view
.subckt sky130_fd_sc_hd__decap_6 VGND VNB VPB VPWR
.ends

* Black-box entry subcircuit for sky130_ef_sc_hd__decap_12 abstract view
.subckt sky130_ef_sc_hd__decap_12 VPWR VGND VPB VNB
.ends

* Black-box entry subcircuit for sky130_fd_sc_hd__decap_4 abstract view
.subckt sky130_fd_sc_hd__decap_4 VGND VNB VPB VPWR
.ends

* Black-box entry subcircuit for sky130_fd_sc_hd__fill_2 abstract view
.subckt sky130_fd_sc_hd__fill_2 VGND VNB VPB VPWR
.ends

* Black-box entry subcircuit for sky130_fd_sc_hd__clkbuf_4 abstract view
.subckt sky130_fd_sc_hd__clkbuf_4 A VGND VNB VPB VPWR X
.ends

* Black-box entry subcircuit for sky130_fd_sc_hd__decap_8 abstract view
.subckt sky130_fd_sc_hd__decap_8 VGND VNB VPB VPWR
.ends

.subckt Mux VGND VNB VPB VPWR Y A B S
X0 a_462_47# B a_76_199# VNB sky130_fd_pr__nfet_01v8 ad=0.0756 pd=0.78 as=0.0567 ps=0.69 w=0.42 l=0.15
X1 a_176_293# S VPWR VPB sky130_fd_pr__pfet_01v8 ad=0.109 pd=1.36 as=0.0567 ps=0.69 w=0.42 l=0.15
X2 VPWR A a_564_374# VPB sky130_fd_pr__pfet_01v8 ad=0.0567 pd=0.69 as=0.0746 ps=0.775 w=0.42 l=0.15
X3 a_76_199# B a_206_374# VPB sky130_fd_pr__pfet_01v8 ad=0.0756 pd=0.78 as=0.237 ps=1.73 w=0.42 l=0.15
X4 a_76_199# a_176_293# a_269_47# VNB sky130_fd_pr__nfet_01v8 ad=0.0567 pd=0.69 as=0.083 ps=0.815 w=0.42 l=0.15
X5 a_564_374# S a_76_199# VPB sky130_fd_pr__pfet_01v8 ad=0.0746 pd=0.775 as=0.0756 ps=0.78 w=0.42 l=0.15
X6 a_269_47# A VGND VNB sky130_fd_pr__nfet_01v8 ad=0.083 pd=0.815 as=0.166 ps=1.3 w=0.42 l=0.15
X7 a_176_293# S VGND VNB sky130_fd_pr__nfet_01v8 ad=0.109 pd=1.36 as=0.163 ps=1.2 w=0.42 l=0.15
X8 VPWR a_76_199# Y VPB sky130_fd_pr__pfet_01v8 ad=0.146 pd=1.34 as=0.26 ps=2.52 w=1 l=0.15
X9 VGND S a_462_47# VNB sky130_fd_pr__nfet_01v8 ad=0.163 pd=1.2 as=0.0756 ps=0.78 w=0.42 l=0.15
X10 a_206_374# a_176_293# VPWR VPB sky130_fd_pr__pfet_01v8 ad=0.237 pd=1.73 as=0.146 ps=1.34 w=0.42 l=0.15
X11 VGND a_76_199# Y VNB sky130_fd_pr__nfet_01v8 ad=0.166 pd=1.3 as=0.169 ps=1.82 w=0.65 l=0.15
.ends

* Black-box entry subcircuit for sky130_fd_sc_hd__buf_2 abstract view
.subckt sky130_fd_sc_hd__buf_2 A VGND VNB VPB VPWR X
.ends

* Black-box entry subcircuit for sky130_fd_sc_hd__buf_4 abstract view
.subckt sky130_fd_sc_hd__buf_4 A VGND VNB VPB VPWR X
.ends

* Black-box entry subcircuit for sky130_fd_sc_hd__buf_1 abstract view
.subckt sky130_fd_sc_hd__buf_1 A VGND VNB VPB VPWR X
.ends

* Black-box entry subcircuit for sky130_fd_sc_hd__dlymetal6s2s_1 abstract view
.subckt sky130_fd_sc_hd__dlymetal6s2s_1 A VGND VNB VPB VPWR X
.ends

* Black-box entry subcircuit for sky130_fd_sc_hd__clkbuf_2 abstract view
.subckt sky130_fd_sc_hd__clkbuf_2 A VGND VNB VPB VPWR X
.ends

* Black-box entry subcircuit for sky130_fd_sc_hd__clkbuf_1 abstract view
.subckt sky130_fd_sc_hd__clkbuf_1 A VGND VNB VPB VPWR X
.ends

* Black-box entry subcircuit for sky130_fd_sc_hd__inv_2 abstract view
.subckt sky130_fd_sc_hd__inv_2 A VGND VNB VPB VPWR Y
.ends

* Black-box entry subcircuit for sky130_fd_sc_hd__diode_2 abstract view
.subckt sky130_fd_sc_hd__diode_2 DIODE VGND VNB VPB VPWR
.ends

.subckt ALU VGND VPWR a[0] a[10] a[11] a[12] a[13] a[14] a[15] a[16] a[17] a[18] a[19]
+ a[1] a[20] a[21] a[22] a[23] a[24] a[25] a[26] a[27] a[28] a[29] a[2] a[30] a[31]
+ a[3] a[4] a[5] a[6] a[7] a[8] a[9] alu_control[0] alu_control[1] alu_control[2]
+ alu_control[3] b[0] b[10] b[11] b[12] b[13] b[14] b[15] b[16] b[17] b[18] b[19]
+ b[1] b[20] b[21] b[22] b[23] b[24] b[25] b[26] b[27] b[28] b[29] b[2] b[30] b[31]
+ b[3] b[4] b[5] b[6] b[7] b[8] b[9] result[0] result[10] result[11] result[12] result[13]
+ result[14] result[15] result[16] result[17] result[18] result[19] result[1] result[20]
+ result[21] result[22] result[23] result[24] result[25] result[26] result[27] result[28]
+ result[29] result[2] result[30] result[31] result[3] result[4] result[5] result[6]
+ result[7] result[8] result[9] zero
X_3086_ VGND VGND VPWR VPWR _0017_ _2076_ inverter
XTAP_177 VGND VPWR sky130_fd_sc_hd__tapvpwrvgnd_1
XTAP_188 VGND VPWR sky130_fd_sc_hd__tapvpwrvgnd_1
X_3155_ VPWR VGND VGND VPWR net68 _0091_ _0090_ Xnor
XTAP_199 VGND VPWR sky130_fd_sc_hd__tapvpwrvgnd_1
X_2939_ VGND VGND VPWR VPWR _2036_ _2042_ _2043_ Nor_gate
X_3988_ VGND VGND VPWR VPWR _0269_ _0993_ _0991_ Nand_gate
XFILLER_0_17_200 VGND VGND VPWR VPWR sky130_fd_sc_hd__fill_1
XFILLER_0_17_233 VGND VGND VPWR VPWR sky130_fd_sc_hd__decap_3
XFILLER_0_32_236 VGND VGND VPWR VPWR sky130_fd_sc_hd__decap_6
XFILLER_0_7_70 VGND VGND VPWR VPWR sky130_fd_sc_hd__fill_1
XFILLER_0_23_247 VGND VGND VPWR VPWR sky130_fd_sc_hd__fill_1
XFILLER_0_23_225 VGND VGND VPWR VPWR sky130_fd_sc_hd__fill_1
XFILLER_0_48_15 VPWR VGND VPWR VGND sky130_ef_sc_hd__decap_12
XFILLER_0_3_39 VPWR VGND VPWR VGND sky130_ef_sc_hd__decap_12
XFILLER_0_58_133 VGND VGND VPWR VPWR sky130_fd_sc_hd__decap_6
XFILLER_0_58_111 VGND VGND VPWR VPWR sky130_fd_sc_hd__fill_1
X_3842_ VGND VGND VPWR VPWR _0452_ _0835_ _0387_ Nand_gate
XFILLER_0_13_73 VPWR VGND VPWR VGND sky130_ef_sc_hd__decap_12
X_3911_ VGND VGND VPWR VPWR net51 _0910_ _0393_ Nand_gate
X_2724_ VGND VGND VPWR VPWR _1726_ _1830_ _1831_ Nor_gate
X_2655_ VGND VGND VPWR VPWR _1648_ _1762_ _1763_ Nor_gate
X_3773_ VGND VGND VPWR VPWR _0555_ _0760_ _0759_ Nand_gate
XFILLER_0_13_95 VGND VGND VPWR VPWR sky130_fd_sc_hd__decap_4
XFILLER_0_14_269 VGND VGND VPWR VPWR sky130_fd_sc_hd__decap_6
X_4187_ VGND VGND VPWR VPWR _1043_ _1207_ _1206_ Nand_gate
X_2586_ VGND VGND VPWR VPWR _1695_ _1694_ inverter
X_4256_ VGND VGND VPWR VPWR _1258_ _1282_ _1281_ Nand_gate
X_4325_ VGND VGND VPWR VPWR _0073_ _1873_ _1356_ Nor_gate
X_3207_ VGND VGND VPWR VPWR _0101_ _0147_ _0148_ Nor_gate
XFILLER_0_54_91 VGND VGND VPWR VPWR sky130_fd_sc_hd__fill_2
XFILLER_0_49_122 VGND VGND VPWR VPWR sky130_fd_sc_hd__decap_4
XFILLER_0_49_111 VGND VGND VPWR VPWR sky130_fd_sc_hd__fill_1
X_3069_ _1677_ VGND VGND VPWR VPWR _0001_ sky130_fd_sc_hd__clkbuf_4
X_3138_ VGND VGND VPWR VPWR _1791_ _0072_ _0074_ Nor_gate
XFILLER_0_52_309 VPWR VGND VPWR VGND sky130_ef_sc_hd__decap_12
XFILLER_0_18_29 VGND VGND VPWR VPWR sky130_fd_sc_hd__fill_1
XFILLER_0_50_27 VGND VGND VPWR VPWR sky130_fd_sc_hd__fill_1
XFILLER_0_28_339 VGND VGND VPWR VPWR sky130_fd_sc_hd__fill_1
X_2440_ VGND VGND VPWR VPWR _1548_ _1549_ net54 Nand_gate
X_4041_ VGND VGND VPWR VPWR _0738_ _0143_ _1050_ Nor_gate
X_4110_ VGND VGND VPWR VPWR _0511_ _1124_ _1125_ Nor_gate
X_2371_ VGND VGND VPWR VPWR _1122_ _1479_ _1480_ Nor_gate
XFILLER_0_54_191 VGND VGND VPWR VPWR sky130_fd_sc_hd__decap_4
XFILLER_0_46_125 VPWR VGND VPWR VGND sky130_ef_sc_hd__decap_12
XFILLER_0_34_309 VGND VGND VPWR VPWR sky130_fd_sc_hd__fill_1
X_3756_ VGND VGND VPWR VPWR _1911_ _0742_ _0741_ Nand_gate
XFILLER_0_19_328 VGND VGND VPWR VPWR sky130_fd_sc_hd__fill_2
XFILLER_0_6_200 VGND VGND VPWR VPWR sky130_fd_sc_hd__decap_8
XFILLER_0_6_244 VGND VGND VPWR VPWR sky130_fd_sc_hd__decap_8
X_3825_ VGND VGND VPWR VPWR _0789_ _0816_ _0817_ Nor_gate
X_2638_ VGND VGND VPWR VPWR _1746_ _1745_ inverter
X_2707_ VGND VGND VPWR VPWR _1440_ _1813_ _1814_ Nor_gate
X_2569_ VGND VGND VPWR VPWR _1678_ net34 inverter
X_3687_ VGND VGND VPWR VPWR _0667_ _0548_ inverter
X_4239_ VGND VGND VPWR VPWR _0686_ _1263_ _1264_ Nor_gate
X_4308_ VGND VGND VPWR VPWR _0042_ _1336_ _1338_ Nor_gate
XFILLER_0_4_93 VGND VGND VPWR VPWR sky130_fd_sc_hd__decap_3
XFILLER_0_52_139 VGND VGND VPWR VPWR sky130_fd_sc_hd__fill_1
XFILLER_0_45_180 VGND VGND VPWR VPWR sky130_fd_sc_hd__fill_1
XFILLER_0_45_49 VGND VGND VPWR VPWR sky130_fd_sc_hd__decap_6
XFILLER_0_45_27 VPWR VGND VPWR VGND sky130_ef_sc_hd__decap_12
XFILLER_0_0_29 VGND VGND VPWR VPWR sky130_fd_sc_hd__fill_2
XFILLER_0_36_180 VGND VGND VPWR VPWR sky130_fd_sc_hd__decap_4
X_3610_ VGND VGND VPWR VPWR _0787_ _0585_ net44 Nand_gate
XFILLER_0_9_49 VGND VGND VPWR VPWR sky130_fd_sc_hd__fill_1
XFILLER_0_16_309 VGND VGND VPWR VPWR sky130_fd_sc_hd__fill_1
XFILLER_0_36_191 VGND VGND VPWR VPWR sky130_fd_sc_hd__fill_1
XFILLER_0_24_342 VGND VGND VPWR VPWR sky130_fd_sc_hd__fill_1
X_3541_ VGND VGND VPWR VPWR _0510_ _0509_ inverter
X_3472_ VGND VGND VPWR VPWR _0042_ _0434_ _0435_ Nor_gate
XFILLER_0_10_41 VGND VGND VPWR VPWR sky130_fd_sc_hd__decap_4
XFILLER_0_10_52 VGND VGND VPWR VPWR sky130_fd_sc_hd__decap_4
XFILLER_0_10_85 VGND VGND VPWR VPWR sky130_fd_sc_hd__fill_2
X_2423_ VGND VGND VPWR VPWR _0387_ _1531_ _1532_ Nor_gate
X_4024_ VGND VGND VPWR VPWR _1031_ _1030_ inverter
X_2354_ VGND VGND VPWR VPWR _1460_ _1462_ _1463_ Nor_gate
X_2285_ VGND VGND VPWR VPWR _1251_ _1262_ _1273_ Nor_gate
XFILLER_0_35_82 VGND VGND VPWR VPWR sky130_fd_sc_hd__decap_8
XFILLER_0_19_147 VGND VGND VPWR VPWR sky130_fd_sc_hd__decap_4
X_3808_ VGND VGND VPWR VPWR _0799_ _0575_ _0797_ _1870_ Mux
XFILLER_0_34_139 VGND VGND VPWR VPWR sky130_fd_sc_hd__fill_1
XFILLER_0_34_117 VGND VGND VPWR VPWR sky130_fd_sc_hd__fill_1
XFILLER_0_30_312 VPWR VGND VPWR VGND sky130_ef_sc_hd__decap_12
X_3739_ VGND VGND VPWR VPWR _0720_ _0723_ _0724_ Nor_gate
XFILLER_0_2_280 VPWR VGND VPWR VGND sky130_ef_sc_hd__decap_12
XFILLER_0_21_334 VGND VGND VPWR VPWR sky130_fd_sc_hd__fill_2
XFILLER_0_21_301 VGND VGND VPWR VPWR sky130_fd_sc_hd__fill_1
XFILLER_0_0_239 VGND VGND VPWR VPWR sky130_fd_sc_hd__fill_2
XFILLER_0_56_15 VPWR VGND VPWR VGND sky130_ef_sc_hd__decap_12
XFILLER_0_48_209 VGND VGND VPWR VPWR sky130_fd_sc_hd__decap_4
X_2972_ VPWR VGND VGND VPWR net64 _2075_ _2024_ Xnor
XFILLER_0_31_109 VGND VGND VPWR VPWR sky130_fd_sc_hd__decap_3
XFILLER_0_16_128 VGND VGND VPWR VPWR sky130_fd_sc_hd__decap_3
X_3455_ VGND VGND VPWR VPWR _0416_ _0415_ inverter
X_3524_ VGND VGND VPWR VPWR _0490_ _0369_ _0491_ Nor_gate
X_2406_ VGND VGND VPWR VPWR _1515_ _0722_ inverter
XFILLER_0_12_323 VPWR VGND VPWR VGND sky130_ef_sc_hd__decap_12
X_3386_ VGND VGND VPWR VPWR _1791_ _0341_ _0342_ Nor_gate
XFILLER_0_46_92 VGND VGND VPWR VPWR sky130_fd_sc_hd__fill_1
X_2337_ VGND VGND VPWR VPWR _1426_ _1446_ _1445_ Nand_gate
XFILLER_0_34_3 VPWR VGND VPWR VGND sky130_ef_sc_hd__decap_12
X_4007_ VGND VGND VPWR VPWR _1013_ _1012_ inverter
X_2268_ VGND VGND VPWR VPWR net32 net68 _1089_ Nor_gate
X_2199_ VGND VGND VPWR VPWR _0333_ net51 _0344_ Nor_gate
XFILLER_0_30_197 VGND VGND VPWR VPWR sky130_fd_sc_hd__decap_6
XFILLER_0_38_253 VPWR VGND VPWR VGND sky130_ef_sc_hd__decap_12
XFILLER_0_38_242 VGND VGND VPWR VPWR sky130_fd_sc_hd__decap_8
XTAP_348 VGND VPWR sky130_fd_sc_hd__tapvpwrvgnd_1
XTAP_337 VGND VPWR sky130_fd_sc_hd__tapvpwrvgnd_1
XTAP_326 VGND VPWR sky130_fd_sc_hd__tapvpwrvgnd_1
X_3240_ VGND VGND VPWR VPWR _1636_ _0174_ _0184_ Nor_gate
XTAP_315 VGND VPWR sky130_fd_sc_hd__tapvpwrvgnd_1
XTAP_304 VGND VPWR sky130_fd_sc_hd__tapvpwrvgnd_1
XFILLER_0_21_142 VGND VGND VPWR VPWR sky130_fd_sc_hd__decap_8
XTAP_359 VGND VPWR sky130_fd_sc_hd__tapvpwrvgnd_1
X_3171_ VGND VGND VPWR VPWR _0102_ _1756_ _0109_ Nor_gate
XFILLER_0_44_212 VPWR VGND VPWR VGND sky130_ef_sc_hd__decap_12
XFILLER_0_44_201 VGND VGND VPWR VPWR sky130_fd_sc_hd__decap_8
XFILLER_0_29_253 VGND VGND VPWR VPWR sky130_fd_sc_hd__decap_3
X_2955_ VGND VGND VPWR VPWR net64 _2059_ _2002_ Nand_gate
XFILLER_0_8_103 VGND VGND VPWR VPWR sky130_fd_sc_hd__decap_8
X_2886_ VGND VGND VPWR VPWR _1991_ _1660_ _1665_ _1713_ Mux
X_3507_ VGND VGND VPWR VPWR _0473_ _0472_ inverter
X_3438_ VGND VGND VPWR VPWR _0399_ _0397_ inverter
X_3369_ VGND VGND VPWR VPWR _1681_ _0323_ _0324_ Nor_gate
XFILLER_0_12_186 VGND VGND VPWR VPWR sky130_fd_sc_hd__decap_4
XFILLER_0_35_223 VGND VGND VPWR VPWR sky130_fd_sc_hd__fill_1
XFILLER_0_7_180 VGND VGND VPWR VPWR sky130_fd_sc_hd__decap_4
Xoutput75 net75 VGND VGND VPWR VPWR result[15] sky130_fd_sc_hd__clkbuf_4
Xoutput97 net97 VGND VGND VPWR VPWR result[6] sky130_fd_sc_hd__clkbuf_4
XFILLER_0_53_27 VPWR VGND VPWR VGND sky130_ef_sc_hd__decap_12
Xoutput86 net86 VGND VGND VPWR VPWR result[25] sky130_fd_sc_hd__buf_2
XFILLER_0_58_315 VGND VGND VPWR VPWR sky130_fd_sc_hd__decap_8
X_2671_ VPWR VGND VGND VPWR _1588_ _1779_ _1778_ Xnor
X_2740_ VGND VGND VPWR VPWR _1838_ _1847_ _1846_ Nand_gate
XFILLER_0_5_117 VGND VGND VPWR VPWR sky130_fd_sc_hd__fill_2
X_4272_ VGND VGND VPWR VPWR _0094_ _1299_ _1255_ Nand_gate
X_3223_ VGND VGND VPWR VPWR _0161_ _0164_ _0165_ Nor_gate
XTAP_145 VGND VPWR sky130_fd_sc_hd__tapvpwrvgnd_1
XTAP_134 VGND VPWR sky130_fd_sc_hd__tapvpwrvgnd_1
XTAP_123 VGND VPWR sky130_fd_sc_hd__tapvpwrvgnd_1
XTAP_156 VGND VPWR sky130_fd_sc_hd__tapvpwrvgnd_1
XTAP_167 VGND VPWR sky130_fd_sc_hd__tapvpwrvgnd_1
XTAP_178 VGND VPWR sky130_fd_sc_hd__tapvpwrvgnd_1
XTAP_189 VGND VPWR sky130_fd_sc_hd__tapvpwrvgnd_1
X_4341_ VGND VGND VPWR VPWR _0277_ _1373_ _0414_ Nand_gate
XFILLER_0_49_337 VGND VGND VPWR VPWR sky130_fd_sc_hd__decap_6
X_3085_ VGND VGND VPWR VPWR _1965_ _0016_ _0015_ Nand_gate
X_3154_ VGND VGND VPWR VPWR _1813_ _0089_ _0090_ Nor_gate
X_2938_ VGND VGND VPWR VPWR _1644_ _2041_ _2042_ Nor_gate
X_3987_ VGND VGND VPWR VPWR _1662_ _0991_ _0989_ Nand_gate
XFILLER_0_17_245 VPWR VGND VPWR VGND sky130_ef_sc_hd__decap_12
X_2869_ VGND VGND VPWR VPWR _1965_ _1974_ _1972_ Nand_gate
XFILLER_0_7_82 VGND VGND VPWR VPWR sky130_fd_sc_hd__fill_1
XFILLER_0_2_109 VPWR VGND VPWR VGND sky130_ef_sc_hd__decap_12
XFILLER_0_48_27 VGND VGND VPWR VPWR sky130_fd_sc_hd__fill_1
XFILLER_0_31_281 VGND VGND VPWR VPWR sky130_fd_sc_hd__fill_1
XFILLER_0_58_167 VGND VGND VPWR VPWR sky130_fd_sc_hd__fill_1
XFILLER_0_46_307 VGND VGND VPWR VPWR sky130_fd_sc_hd__fill_1
X_2723_ VGND VGND VPWR VPWR _1830_ _1828_ _1829_ _1633_ Mux
X_3910_ VGND VGND VPWR VPWR _0897_ _0908_ _0909_ Nor_gate
X_3772_ VGND VGND VPWR VPWR _0759_ _0758_ inverter
X_3841_ VGND VGND VPWR VPWR _0387_ _0833_ _0834_ Nor_gate
XFILLER_0_13_85 VGND VGND VPWR VPWR sky130_fd_sc_hd__fill_1
X_2654_ VGND VGND VPWR VPWR _1762_ _1761_ inverter
X_2585_ VGND VGND VPWR VPWR _1681_ _1693_ _1694_ Nor_gate
X_4324_ VGND VGND VPWR VPWR _0051_ _0001_ _1355_ Nor_gate
XFILLER_0_38_82 VGND VGND VPWR VPWR sky130_fd_sc_hd__fill_2
X_4186_ VGND VGND VPWR VPWR _1206_ _1149_ inverter
X_4255_ VGND VGND VPWR VPWR _1267_ _1280_ _1281_ Nor_gate
X_3206_ VGND VGND VPWR VPWR _0112_ _0147_ _0146_ Nand_gate
X_3137_ VGND VGND VPWR VPWR _1478_ _2167_ _0072_ Nor_gate
XFILLER_0_49_134 VGND VGND VPWR VPWR sky130_fd_sc_hd__decap_6
X_3068_ VGND VGND VPWR VPWR _2167_ _0000_ _2169_ Nand_gate
XFILLER_0_9_253 VGND VGND VPWR VPWR sky130_fd_sc_hd__decap_3
XFILLER_0_55_137 VPWR VGND VPWR VGND sky130_ef_sc_hd__decap_12
XFILLER_0_28_307 VGND VGND VPWR VPWR sky130_fd_sc_hd__fill_1
X_4040_ VGND VGND VPWR VPWR _1766_ _1049_ _1048_ Nand_gate
X_2370_ VGND VGND VPWR VPWR _1478_ _1479_ net67 Nand_gate
XFILLER_0_46_137 VGND VGND VPWR VPWR sky130_fd_sc_hd__decap_3
XFILLER_0_42_321 VPWR VGND VPWR VGND sky130_ef_sc_hd__decap_12
X_2706_ _1777_ VGND VGND VPWR VPWR _1813_ sky130_fd_sc_hd__clkbuf_4
X_3755_ VGND VGND VPWR VPWR _0108_ _1648_ _0741_ Nor_gate
X_3686_ VGND VGND VPWR VPWR _0665_ _0533_ _0666_ Nor_gate
X_3824_ VGND VGND VPWR VPWR _0793_ _0816_ _0815_ Nand_gate
X_2499_ _1607_ VGND VGND VPWR VPWR _1608_ sky130_fd_sc_hd__clkbuf_4
X_2637_ VGND VGND VPWR VPWR _1745_ _1740_ _1744_ _1712_ Mux
X_2568_ VGND VGND VPWR VPWR net36 _1677_ _1647_ Nand_gate
X_4307_ VGND VGND VPWR VPWR _1331_ _1334_ _1336_ Nor_gate
XFILLER_0_10_251 VGND VGND VPWR VPWR sky130_fd_sc_hd__fill_1
X_4238_ VGND VGND VPWR VPWR _1263_ _0846_ _1261_ _0135_ Mux
X_4169_ VGND VGND VPWR VPWR net20 _1137_ _1188_ Nor_gate
XFILLER_0_4_83 VGND VGND VPWR VPWR sky130_fd_sc_hd__fill_1
XFILLER_0_37_137 VGND VGND VPWR VPWR sky130_fd_sc_hd__fill_2
XFILLER_0_37_104 VGND VGND VPWR VPWR sky130_fd_sc_hd__fill_2
XFILLER_0_45_39 VGND VGND VPWR VPWR sky130_fd_sc_hd__fill_1
XFILLER_0_28_148 VGND VGND VPWR VPWR sky130_fd_sc_hd__decap_4
XFILLER_0_28_137 VGND VGND VPWR VPWR sky130_fd_sc_hd__decap_3
X_3540_ VGND VGND VPWR VPWR _0228_ _0508_ _0509_ Nor_gate
XFILLER_0_51_195 VGND VGND VPWR VPWR sky130_fd_sc_hd__decap_8
XFILLER_0_51_184 VGND VGND VPWR VPWR sky130_fd_sc_hd__fill_2
X_2353_ VGND VGND VPWR VPWR net63 _1462_ _1461_ Nand_gate
X_3471_ VGND VGND VPWR VPWR _0421_ _0432_ _0434_ Nor_gate
XFILLER_0_10_97 VGND VGND VPWR VPWR sky130_fd_sc_hd__fill_1
X_2422_ VGND VGND VPWR VPWR _1531_ net50 inverter
X_4023_ VPWR VGND VGND VPWR net54 _1030_ _1029_ Xnor
X_2284_ VGND VGND VPWR VPWR _1230_ net39 _1262_ Nor_gate
XFILLER_0_19_137 VGND VGND VPWR VPWR sky130_fd_sc_hd__decap_4
XFILLER_0_19_104 VGND VGND VPWR VPWR sky130_fd_sc_hd__fill_2
X_3807_ VGND VGND VPWR VPWR _0797_ _0696_ _0796_ _2155_ Mux
XFILLER_0_42_184 VGND VGND VPWR VPWR sky130_fd_sc_hd__fill_2
X_3738_ VGND VGND VPWR VPWR _0676_ _0723_ _0721_ Nand_gate
X_3669_ VGND VGND VPWR VPWR _0621_ _0648_ _0649_ Nor_gate
XFILLER_0_15_310 VGND VGND VPWR VPWR sky130_fd_sc_hd__decap_3
XFILLER_0_2_292 VPWR VGND VPWR VGND sky130_ef_sc_hd__decap_12
XFILLER_0_18_192 VGND VGND VPWR VPWR sky130_fd_sc_hd__decap_4
XFILLER_0_33_184 VGND VGND VPWR VPWR sky130_fd_sc_hd__fill_1
XFILLER_0_21_324 VGND VGND VPWR VPWR sky130_fd_sc_hd__fill_1
XFILLER_0_56_27 VGND VGND VPWR VPWR sky130_fd_sc_hd__fill_1
X_2971_ VPWR VGND VGND VPWR net29 _2074_ _2073_ Xnor
XFILLER_0_8_307 VGND VGND VPWR VPWR sky130_fd_sc_hd__fill_1
X_3523_ VGND VGND VPWR VPWR _0490_ _0852_ inverter
XFILLER_0_12_335 VPWR VGND VPWR VGND sky130_ef_sc_hd__decap_12
XFILLER_0_16_107 VGND VGND VPWR VPWR sky130_fd_sc_hd__fill_1
X_2336_ VGND VGND VPWR VPWR _1445_ _1444_ inverter
X_3454_ VGND VGND VPWR VPWR net41 net40 _0415_ Nor_gate
X_2405_ VGND VGND VPWR VPWR _0733_ _0755_ _1514_ Nor_gate
X_3385_ VGND VGND VPWR VPWR _0959_ _0339_ _0341_ Nor_gate
X_2198_ net15 VGND VGND VPWR VPWR _0333_ sky130_fd_sc_hd__clkbuf_4
X_4006_ VGND VGND VPWR VPWR _0108_ _0067_ _1012_ Nor_gate
X_2267_ VGND VGND VPWR VPWR _0949_ _1078_ _1068_ Nand_gate
XFILLER_0_15_151 VGND VGND VPWR VPWR sky130_fd_sc_hd__decap_6
XFILLER_0_26_19 VGND VGND VPWR VPWR sky130_fd_sc_hd__fill_1
XFILLER_0_42_29 VGND VGND VPWR VPWR sky130_fd_sc_hd__fill_2
XFILLER_0_38_265 VGND VGND VPWR VPWR sky130_fd_sc_hd__decap_6
XFILLER_0_38_221 VGND VGND VPWR VPWR sky130_fd_sc_hd__decap_3
XFILLER_0_53_279 VGND VGND VPWR VPWR sky130_fd_sc_hd__fill_1
XTAP_349 VGND VPWR sky130_fd_sc_hd__tapvpwrvgnd_1
XTAP_338 VGND VPWR sky130_fd_sc_hd__tapvpwrvgnd_1
XTAP_327 VGND VPWR sky130_fd_sc_hd__tapvpwrvgnd_1
XTAP_316 VGND VPWR sky130_fd_sc_hd__tapvpwrvgnd_1
XTAP_305 VGND VPWR sky130_fd_sc_hd__tapvpwrvgnd_1
X_3170_ _1650_ VGND VGND VPWR VPWR _0108_ sky130_fd_sc_hd__buf_2
XFILLER_0_21_187 VGND VGND VPWR VPWR sky130_fd_sc_hd__fill_1
XFILLER_0_21_165 VGND VGND VPWR VPWR sky130_fd_sc_hd__decap_3
XFILLER_0_6_29 VPWR VGND VPWR VGND sky130_ef_sc_hd__decap_12
XFILLER_0_16_85 VPWR VGND VPWR VGND sky130_ef_sc_hd__decap_12
XFILLER_0_44_257 VGND VGND VPWR VPWR sky130_fd_sc_hd__fill_1
XFILLER_0_44_224 VGND VGND VPWR VPWR sky130_fd_sc_hd__decap_4
X_2885_ VGND VGND VPWR VPWR _1981_ _1989_ _1990_ Nor_gate
X_2954_ VGND VGND VPWR VPWR _1458_ _2057_ _2058_ Nor_gate
X_3506_ VGND VGND VPWR VPWR _0462_ _0471_ _0472_ Nor_gate
XFILLER_0_57_81 VPWR VGND VPWR VGND sky130_ef_sc_hd__decap_12
X_2319_ net23 VGND VGND VPWR VPWR _1428_ sky130_fd_sc_hd__buf_2
X_3299_ VGND VGND VPWR VPWR _2000_ _0247_ _0248_ Nor_gate
X_3437_ VGND VGND VPWR VPWR _0906_ _0396_ _0397_ Nor_gate
X_3368_ VGND VGND VPWR VPWR _0323_ _1800_ _1693_ _0981_ Mux
XFILLER_0_50_249 VGND VGND VPWR VPWR sky130_fd_sc_hd__decap_3
XFILLER_0_35_279 VGND VGND VPWR VPWR sky130_fd_sc_hd__fill_1
XFILLER_0_35_257 VPWR VGND VPWR VGND sky130_ef_sc_hd__decap_12
Xoutput87 net87 VGND VGND VPWR VPWR result[26] sky130_fd_sc_hd__clkbuf_4
Xoutput98 net98 VGND VGND VPWR VPWR result[7] sky130_fd_sc_hd__clkbuf_4
Xoutput76 net76 VGND VGND VPWR VPWR result[16] sky130_fd_sc_hd__clkbuf_4
XFILLER_0_53_39 VGND VGND VPWR VPWR sky130_fd_sc_hd__fill_2
XFILLER_0_26_213 VGND VGND VPWR VPWR sky130_fd_sc_hd__decap_3
X_2670_ VGND VGND VPWR VPWR _1585_ _1777_ _1778_ Nor_gate
X_4340_ VGND VGND VPWR VPWR net92 _1371_ _1372_ Nor_gate
X_4271_ VGND VGND VPWR VPWR _0094_ _1255_ _1298_ Nor_gate
X_3222_ VGND VGND VPWR VPWR _0163_ _0164_ _0026_ Nand_gate
XTAP_146 VGND VPWR sky130_fd_sc_hd__tapvpwrvgnd_1
XTAP_135 VGND VPWR sky130_fd_sc_hd__tapvpwrvgnd_1
XTAP_124 VGND VPWR sky130_fd_sc_hd__tapvpwrvgnd_1
XTAP_157 VGND VPWR sky130_fd_sc_hd__tapvpwrvgnd_1
XTAP_168 VGND VPWR sky130_fd_sc_hd__tapvpwrvgnd_1
XTAP_179 VGND VPWR sky130_fd_sc_hd__tapvpwrvgnd_1
X_3153_ VGND VGND VPWR VPWR net67 _0034_ _0089_ Nor_gate
X_3084_ VGND VGND VPWR VPWR _2085_ _0014_ _0015_ Nor_gate
X_2937_ VGND VGND VPWR VPWR _2033_ _2040_ _2041_ Nor_gate
X_3986_ VGND VGND VPWR VPWR _1662_ _0989_ _0990_ Nor_gate
X_2868_ VGND VGND VPWR VPWR _1965_ _1972_ _1973_ Nor_gate
XFILLER_0_4_151 VGND VGND VPWR VPWR sky130_fd_sc_hd__fill_1
XFILLER_0_17_257 VGND VGND VPWR VPWR sky130_fd_sc_hd__decap_8
XFILLER_0_17_268 VPWR VGND VPWR VGND sky130_ef_sc_hd__decap_12
X_2799_ VGND VGND VPWR VPWR _1905_ _1738_ _1741_ _1588_ Mux
XFILLER_0_4_195 VGND VGND VPWR VPWR sky130_fd_sc_hd__fill_1
XFILLER_0_4_184 VGND VGND VPWR VPWR sky130_fd_sc_hd__fill_2
XFILLER_0_7_94 VPWR VGND VPWR VGND sky130_ef_sc_hd__decap_12
XFILLER_0_31_271 VGND VGND VPWR VPWR sky130_fd_sc_hd__decap_8
XFILLER_0_58_113 VGND VGND VPWR VPWR sky130_fd_sc_hd__fill_2
XFILLER_0_54_341 VGND VGND VPWR VPWR sky130_fd_sc_hd__fill_2
X_2722_ VGND VGND VPWR VPWR _1829_ _1651_ _1631_ _1432_ Mux
X_3771_ VGND VGND VPWR VPWR _0651_ _0758_ _0757_ Nand_gate
X_3840_ VGND VGND VPWR VPWR _0833_ _0790_ inverter
XFILLER_0_14_227 VPWR VGND VPWR VGND sky130_ef_sc_hd__decap_12
X_2653_ VGND VGND VPWR VPWR _1736_ _1761_ _1760_ Nand_gate
X_4323_ VGND VGND VPWR VPWR _1353_ _1354_ _0741_ Nand_gate
X_2584_ VGND VGND VPWR VPWR _1600_ _1692_ _1693_ Nor_gate
XFILLER_0_22_271 VGND VGND VPWR VPWR sky130_fd_sc_hd__fill_2
XFILLER_0_38_61 VGND VGND VPWR VPWR sky130_fd_sc_hd__fill_2
X_4254_ VGND VGND VPWR VPWR _1280_ _1279_ inverter
X_3205_ VGND VGND VPWR VPWR _0120_ _0145_ _0146_ Nor_gate
X_4185_ VGND VGND VPWR VPWR _1202_ _1205_ _1204_ Nand_gate
X_3136_ VGND VGND VPWR VPWR _1478_ _0071_ _2167_ Nand_gate
X_3067_ VGND VGND VPWR VPWR _1791_ _2168_ _2169_ Nor_gate
XFILLER_0_49_113 VGND VGND VPWR VPWR sky130_fd_sc_hd__decap_3
XFILLER_0_37_308 VGND VGND VPWR VPWR sky130_fd_sc_hd__decap_8
X_3969_ VGND VGND VPWR VPWR _0968_ _0972_ _0971_ Nand_gate
XFILLER_0_55_149 VGND VGND VPWR VPWR sky130_fd_sc_hd__fill_2
XFILLER_0_50_29 VPWR VGND VPWR VGND sky130_ef_sc_hd__decap_12
XFILLER_0_24_85 VGND VGND VPWR VPWR sky130_fd_sc_hd__fill_1
XFILLER_0_24_41 VGND VGND VPWR VPWR sky130_fd_sc_hd__decap_4
XFILLER_0_19_308 VPWR VGND VPWR VGND sky130_ef_sc_hd__decap_12
X_3823_ VGND VGND VPWR VPWR _0807_ _0814_ _0815_ Nor_gate
X_2636_ VGND VGND VPWR VPWR _1744_ _1742_ _1743_ _1716_ Mux
XFILLER_0_42_333 VGND VGND VPWR VPWR sky130_fd_sc_hd__decap_4
X_2705_ VGND VGND VPWR VPWR _1811_ _1781_ _1812_ Nor_gate
X_3754_ VGND VGND VPWR VPWR _0594_ _0740_ _0739_ Nand_gate
X_3685_ VGND VGND VPWR VPWR _0662_ _0665_ _0664_ Nand_gate
X_2567_ _1608_ VGND VGND VPWR VPWR _1676_ sky130_fd_sc_hd__clkbuf_4
X_4237_ VGND VGND VPWR VPWR _1261_ _1053_ _1260_ _0379_ Mux
X_2498_ _1433_ VGND VGND VPWR VPWR _1607_ sky130_fd_sc_hd__buf_4
X_4306_ VGND VGND VPWR VPWR _1331_ _1335_ _1334_ Nand_gate
X_4099_ VGND VGND VPWR VPWR _1113_ _1112_ inverter
X_3119_ VGND VGND VPWR VPWR _1441_ _1993_ _0053_ Nor_gate
X_4168_ VGND VGND VPWR VPWR _1085_ _1187_ _1183_ Nand_gate
XFILLER_0_33_322 VGND VGND VPWR VPWR sky130_fd_sc_hd__decap_8
XFILLER_0_33_311 VGND VGND VPWR VPWR sky130_fd_sc_hd__fill_1
X_2352_ VGND VGND VPWR VPWR _1461_ net27 inverter
XFILLER_0_19_74 VPWR VGND VPWR VGND sky130_ef_sc_hd__decap_12
X_3470_ VGND VGND VPWR VPWR _0421_ _0433_ _0432_ Nand_gate
X_2283_ VGND VGND VPWR VPWR _1251_ _1240_ inverter
X_2421_ VGND VGND VPWR VPWR _0333_ _1529_ _1530_ Nor_gate
X_4022_ VGND VGND VPWR VPWR _0355_ _1028_ _1029_ Nor_gate
X_3806_ VGND VGND VPWR VPWR _0796_ _0452_ _0582_ _1608_ Mux
XFILLER_0_51_61 VGND VGND VPWR VPWR sky130_fd_sc_hd__decap_4
X_2619_ VGND VGND VPWR VPWR _1727_ _1475_ net2 _1610_ Mux
XFILLER_0_42_141 VPWR VGND VPWR VGND sky130_ef_sc_hd__decap_12
X_3599_ VGND VGND VPWR VPWR _1924_ _1672_ _0573_ Nor_gate
XFILLER_0_30_336 VGND VGND VPWR VPWR sky130_fd_sc_hd__fill_1
X_3737_ VGND VGND VPWR VPWR _0717_ _0721_ _0719_ Nand_gate
X_3668_ VGND VGND VPWR VPWR _0634_ _0648_ _0646_ Nand_gate
XFILLER_0_0_219 VGND VGND VPWR VPWR sky130_fd_sc_hd__decap_4
X_2970_ VPWR VGND VGND VPWR net65 _2073_ _2072_ Xnor
XFILLER_0_21_20 VPWR VGND VPWR VGND sky130_ef_sc_hd__decap_12
XFILLER_0_24_163 VGND VGND VPWR VPWR sky130_fd_sc_hd__fill_1
XFILLER_0_24_141 VGND VGND VPWR VPWR sky130_fd_sc_hd__decap_4
XFILLER_0_21_86 VGND VGND VPWR VPWR sky130_fd_sc_hd__fill_2
XFILLER_0_21_64 VGND VGND VPWR VPWR sky130_fd_sc_hd__fill_1
X_3522_ VGND VGND VPWR VPWR _0486_ _0489_ _0488_ Nand_gate
X_3453_ VGND VGND VPWR VPWR net73 _0414_ inverter
XFILLER_0_46_50 VGND VGND VPWR VPWR sky130_fd_sc_hd__decap_6
XFILLER_0_41_6 VPWR VGND VPWR VGND sky130_ef_sc_hd__decap_12
X_2335_ VGND VGND VPWR VPWR _1429_ _1443_ _1444_ Nor_gate
X_3384_ VGND VGND VPWR VPWR _0959_ _0340_ _0339_ Nand_gate
X_2266_ VGND VGND VPWR VPWR _1003_ _1057_ _1068_ Nor_gate
X_2404_ VGND VGND VPWR VPWR _1511_ _1512_ _1513_ Nor_gate
X_4005_ VGND VGND VPWR VPWR _0113_ _1010_ _1011_ Nor_gate
X_2197_ VGND VGND VPWR VPWR _0235_ _0322_ _0311_ Nand_gate
XFILLER_0_1_41 VGND VGND VPWR VPWR sky130_fd_sc_hd__fill_1
XFILLER_0_47_277 VGND VGND VPWR VPWR sky130_fd_sc_hd__decap_3
XFILLER_0_15_163 VGND VGND VPWR VPWR sky130_fd_sc_hd__decap_4
XFILLER_0_30_122 VGND VGND VPWR VPWR sky130_fd_sc_hd__fill_1
XFILLER_0_38_200 VGND VGND VPWR VPWR sky130_fd_sc_hd__fill_1
XFILLER_0_53_225 VPWR VGND VPWR VGND sky130_ef_sc_hd__decap_12
XFILLER_0_21_111 VGND VGND VPWR VPWR sky130_fd_sc_hd__fill_1
XFILLER_0_6_19 VGND VGND VPWR VPWR sky130_fd_sc_hd__decap_8
XTAP_339 VGND VPWR sky130_fd_sc_hd__tapvpwrvgnd_1
XTAP_328 VGND VPWR sky130_fd_sc_hd__tapvpwrvgnd_1
XTAP_317 VGND VPWR sky130_fd_sc_hd__tapvpwrvgnd_1
XTAP_306 VGND VPWR sky130_fd_sc_hd__tapvpwrvgnd_1
XFILLER_0_16_97 VGND VGND VPWR VPWR sky130_fd_sc_hd__fill_1
XFILLER_0_32_85 VGND VGND VPWR VPWR sky130_fd_sc_hd__decap_8
XFILLER_0_29_299 VGND VGND VPWR VPWR sky130_fd_sc_hd__decap_8
XFILLER_0_29_233 VGND VGND VPWR VPWR sky130_fd_sc_hd__decap_8
X_2884_ VGND VGND VPWR VPWR _1983_ _1988_ _1989_ Nor_gate
X_2953_ VGND VGND VPWR VPWR _1681_ _2056_ _2057_ Nor_gate
XFILLER_0_4_322 VPWR VGND VPWR VGND sky130_ef_sc_hd__decap_12
XFILLER_0_8_149 VPWR VGND VPWR VGND sky130_ef_sc_hd__decap_12
X_3505_ VGND VGND VPWR VPWR _0467_ _0470_ _0471_ Nor_gate
X_3436_ VGND VGND VPWR VPWR _1682_ _0395_ _0396_ Nor_gate
XFILLER_0_12_155 VGND VGND VPWR VPWR sky130_fd_sc_hd__fill_2
XFILLER_0_57_93 VGND VGND VPWR VPWR sky130_fd_sc_hd__decap_4
X_3298_ VGND VGND VPWR VPWR _0244_ _0247_ _0245_ Nand_gate
X_2318_ VGND VGND VPWR VPWR _1427_ net59 inverter
X_3367_ VGND VGND VPWR VPWR net40 _0321_ _2002_ Nand_gate
X_2249_ VGND VGND VPWR VPWR _0884_ _0873_ inverter
XFILLER_0_50_239 VGND VGND VPWR VPWR sky130_fd_sc_hd__fill_1
XFILLER_0_35_269 VGND VGND VPWR VPWR sky130_fd_sc_hd__decap_4
Xoutput77 net77 VGND VGND VPWR VPWR result[17] sky130_fd_sc_hd__clkbuf_4
Xoutput88 net88 VGND VGND VPWR VPWR result[27] sky130_fd_sc_hd__buf_2
Xoutput99 net99 VGND VGND VPWR VPWR result[8] sky130_fd_sc_hd__clkbuf_4
XFILLER_0_26_225 VGND VGND VPWR VPWR sky130_fd_sc_hd__decap_8
XFILLER_0_26_203 VGND VGND VPWR VPWR sky130_fd_sc_hd__decap_6
XFILLER_0_34_280 VGND VGND VPWR VPWR sky130_fd_sc_hd__decap_4
X_4270_ VGND VGND VPWR VPWR _1293_ _1297_ _1296_ Nand_gate
X_3221_ VGND VGND VPWR VPWR _2079_ _0163_ _0162_ Nand_gate
XTAP_147 VGND VPWR sky130_fd_sc_hd__tapvpwrvgnd_1
XTAP_136 VGND VPWR sky130_fd_sc_hd__tapvpwrvgnd_1
XTAP_125 VGND VPWR sky130_fd_sc_hd__tapvpwrvgnd_1
XTAP_158 VGND VPWR sky130_fd_sc_hd__tapvpwrvgnd_1
XTAP_169 VGND VPWR sky130_fd_sc_hd__tapvpwrvgnd_1
X_3152_ VGND VGND VPWR VPWR _0088_ _1475_ inverter
X_3083_ VGND VGND VPWR VPWR _0013_ _0014_ _2137_ Nand_gate
X_3985_ VGND VGND VPWR VPWR _0891_ _0989_ _0988_ Nand_gate
XFILLER_0_11_7 VPWR VGND VPWR VGND sky130_ef_sc_hd__decap_12
X_2936_ VGND VGND VPWR VPWR _1997_ _2040_ _2039_ Nand_gate
X_2798_ VGND VGND VPWR VPWR _1440_ _1903_ _1904_ Nor_gate
XFILLER_0_32_217 VPWR VGND VPWR VGND sky130_ef_sc_hd__decap_12
XFILLER_0_32_206 VGND VGND VPWR VPWR sky130_fd_sc_hd__decap_8
X_2867_ VGND VGND VPWR VPWR _1970_ _1971_ _1972_ Nor_gate
XFILLER_0_4_163 VGND VGND VPWR VPWR sky130_fd_sc_hd__fill_1
XFILLER_0_17_225 VGND VGND VPWR VPWR sky130_fd_sc_hd__decap_8
X_3419_ VGND VGND VPWR VPWR _0374_ _0377_ _0378_ Nor_gate
XFILLER_0_7_51 VGND VGND VPWR VPWR sky130_fd_sc_hd__decap_4
XFILLER_0_48_29 VPWR VGND VPWR VGND sky130_ef_sc_hd__decap_12
XFILLER_0_23_239 VGND VGND VPWR VPWR sky130_fd_sc_hd__decap_8
XFILLER_0_58_147 VPWR VGND VPWR VGND sky130_ef_sc_hd__decap_12
XFILLER_0_46_309 VPWR VGND VPWR VGND sky130_ef_sc_hd__decap_12
X_2721_ VGND VGND VPWR VPWR _1828_ _1627_ _1630_ _1716_ Mux
X_2652_ VGND VGND VPWR VPWR _1650_ _1760_ _1759_ Nand_gate
X_3770_ VGND VGND VPWR VPWR net47 net46 _0757_ Nor_gate
XFILLER_0_14_206 VPWR VGND VPWR VGND sky130_ef_sc_hd__decap_12
XFILLER_0_14_239 VGND VGND VPWR VPWR sky130_fd_sc_hd__fill_2
X_4253_ VGND VGND VPWR VPWR _1270_ _1278_ _1279_ Nor_gate
X_4322_ VGND VGND VPWR VPWR _0040_ _1699_ _1353_ Nor_gate
X_3204_ VGND VGND VPWR VPWR _0134_ _0145_ _0144_ Nand_gate
XFILLER_0_22_294 VGND VGND VPWR VPWR sky130_fd_sc_hd__fill_2
XFILLER_0_22_250 VGND VGND VPWR VPWR sky130_fd_sc_hd__fill_2
X_2583_ VGND VGND VPWR VPWR net34 _1692_ _1691_ Nand_gate
XFILLER_0_1_111 VGND VGND VPWR VPWR sky130_fd_sc_hd__fill_1
XFILLER_0_1_166 VGND VGND VPWR VPWR sky130_fd_sc_hd__fill_2
X_3135_ VGND VGND VPWR VPWR _0061_ _0069_ _0070_ Nor_gate
X_4184_ VGND VGND VPWR VPWR _0042_ _1203_ _1204_ Nor_gate
X_3066_ VGND VGND VPWR VPWR _1316_ _2125_ _2168_ Nor_gate
X_2919_ VGND VGND VPWR VPWR net63 _1967_ _2023_ Nor_gate
X_3968_ VGND VGND VPWR VPWR _0924_ _0971_ _0969_ Nand_gate
XFILLER_0_9_233 VGND VGND VPWR VPWR sky130_fd_sc_hd__fill_2
X_3899_ VGND VGND VPWR VPWR _2096_ _0794_ _0897_ Nor_gate
XFILLER_0_27_342 VGND VGND VPWR VPWR sky130_fd_sc_hd__fill_1
X_3822_ VGND VGND VPWR VPWR _0808_ _0814_ _0813_ Nand_gate
XFILLER_0_42_301 VGND VGND VPWR VPWR sky130_fd_sc_hd__fill_1
X_2635_ VGND VGND VPWR VPWR _1743_ _1658_ _1662_ net37 Mux
X_3753_ VGND VGND VPWR VPWR _0739_ _1940_ _0737_ _0738_ Mux
XFILLER_0_40_96 VGND VGND VPWR VPWR sky130_fd_sc_hd__decap_6
XFILLER_0_40_85 VGND VGND VPWR VPWR sky130_fd_sc_hd__fill_1
X_2704_ VGND VGND VPWR VPWR _1811_ _1810_ inverter
X_3684_ VGND VGND VPWR VPWR _0286_ _0664_ _0663_ Nand_gate
XFILLER_0_6_269 VGND VGND VPWR VPWR sky130_fd_sc_hd__fill_1
X_2497_ _1605_ VGND VGND VPWR VPWR _1606_ sky130_fd_sc_hd__clkbuf_4
X_4236_ VGND VGND VPWR VPWR _1260_ _1153_ _1259_ _0255_ Mux
XFILLER_0_49_83 VPWR VGND VPWR VGND sky130_ef_sc_hd__decap_12
X_2566_ VGND VGND VPWR VPWR _1641_ _1674_ _1675_ Nor_gate
X_4167_ VGND VGND VPWR VPWR _1094_ _1184_ _1185_ Nor_gate
X_4305_ VPWR VGND VGND VPWR _0073_ _1334_ _1333_ Xnor
XFILLER_0_4_85 VGND VGND VPWR VPWR sky130_fd_sc_hd__decap_8
XFILLER_0_4_41 VPWR VGND VPWR VGND sky130_ef_sc_hd__decap_12
XFILLER_0_10_253 VPWR VGND VPWR VGND sky130_ef_sc_hd__decap_12
X_4098_ VGND VGND VPWR VPWR _1112_ _0201_ _1110_ _0738_ Mux
X_3118_ VGND VGND VPWR VPWR _1671_ _0050_ _0052_ Nor_gate
X_3049_ VGND VGND VPWR VPWR _2146_ _2150_ _2151_ Nor_gate
XFILLER_0_43_109 VGND VGND VPWR VPWR sky130_fd_sc_hd__decap_3
XFILLER_0_36_161 VGND VGND VPWR VPWR sky130_fd_sc_hd__fill_1
XFILLER_0_24_312 VGND VGND VPWR VPWR sky130_fd_sc_hd__decap_4
XFILLER_0_3_228 VGND VGND VPWR VPWR sky130_fd_sc_hd__decap_6
XFILLER_0_10_66 VPWR VGND VPWR VGND sky130_ef_sc_hd__decap_12
X_2420_ VGND VGND VPWR VPWR _1529_ net51 inverter
X_4021_ VGND VGND VPWR VPWR net53 _0977_ _1028_ Nor_gate
X_2351_ VGND VGND VPWR VPWR _1458_ _1459_ _1460_ Nor_gate
XFILLER_0_19_86 VGND VGND VPWR VPWR sky130_fd_sc_hd__decap_3
X_2282_ VGND VGND VPWR VPWR _1230_ _1240_ net39 Nand_gate
XFILLER_0_35_74 VGND VGND VPWR VPWR sky130_fd_sc_hd__fill_2
XFILLER_0_51_84 VGND VGND VPWR VPWR sky130_fd_sc_hd__decap_8
X_3805_ VGND VGND VPWR VPWR _2017_ _0794_ _0795_ Nor_gate
XFILLER_0_34_109 VGND VGND VPWR VPWR sky130_fd_sc_hd__decap_4
XFILLER_0_19_128 VGND VGND VPWR VPWR sky130_fd_sc_hd__decap_3
X_3736_ VGND VGND VPWR VPWR _0717_ _0719_ _0720_ Nor_gate
XFILLER_0_15_345 VGND VGND VPWR VPWR sky130_fd_sc_hd__fill_2
X_2549_ VGND VGND VPWR VPWR _1658_ net16 inverter
XFILLER_0_42_153 VGND VGND VPWR VPWR sky130_fd_sc_hd__fill_2
X_2618_ _1424_ VGND VGND VPWR VPWR _1726_ sky130_fd_sc_hd__clkbuf_4
X_3598_ VGND VGND VPWR VPWR _0568_ _0570_ _0572_ Nor_gate
X_3667_ VGND VGND VPWR VPWR _0638_ _0645_ _0646_ Nor_gate
X_4219_ VGND VGND VPWR VPWR _1198_ _1242_ _1241_ Nand_gate
XFILLER_0_25_109 VGND VGND VPWR VPWR sky130_fd_sc_hd__decap_3
XFILLER_0_18_150 VGND VGND VPWR VPWR sky130_fd_sc_hd__decap_8
XFILLER_0_0_209 VGND VGND VPWR VPWR sky130_fd_sc_hd__decap_4
XFILLER_0_56_29 VPWR VGND VPWR VGND sky130_ef_sc_hd__decap_12
XFILLER_0_21_32 VPWR VGND VPWR VGND sky130_ef_sc_hd__decap_12
XFILLER_0_8_309 VGND VGND VPWR VPWR sky130_fd_sc_hd__fill_1
XFILLER_0_24_197 VGND VGND VPWR VPWR sky130_fd_sc_hd__decap_4
XFILLER_0_24_153 VGND VGND VPWR VPWR sky130_fd_sc_hd__decap_6
X_3521_ VGND VGND VPWR VPWR _0042_ _0487_ _0488_ Nor_gate
X_3452_ VGND VGND VPWR VPWR _0367_ _0413_ _0414_ Nor_gate
X_3383_ VGND VGND VPWR VPWR _0122_ _0338_ _0339_ Nor_gate
X_2403_ VGND VGND VPWR VPWR _1512_ _0690_ inverter
X_2196_ VGND VGND VPWR VPWR _0268_ _0300_ _0311_ Nor_gate
X_2334_ VGND VGND VPWR VPWR _1437_ _1442_ _1443_ Nor_gate
X_4004_ VGND VGND VPWR VPWR _0519_ _1009_ _1010_ Nor_gate
X_2265_ VGND VGND VPWR VPWR _1035_ _1046_ _1057_ Nor_gate
XFILLER_0_47_223 VGND VGND VPWR VPWR sky130_fd_sc_hd__fill_1
XFILLER_0_1_53 VGND VGND VPWR VPWR sky130_fd_sc_hd__decap_3
XFILLER_0_15_142 VGND VGND VPWR VPWR sky130_fd_sc_hd__fill_2
X_3719_ VGND VGND VPWR VPWR _0703_ _1985_ _1984_ _0690_ Mux
XFILLER_0_30_189 VGND VGND VPWR VPWR sky130_fd_sc_hd__fill_1
XFILLER_0_30_156 VGND VGND VPWR VPWR sky130_fd_sc_hd__decap_4
XFILLER_0_21_156 VGND VGND VPWR VPWR sky130_fd_sc_hd__decap_6
XTAP_329 VGND VPWR sky130_fd_sc_hd__tapvpwrvgnd_1
XTAP_318 VGND VPWR sky130_fd_sc_hd__tapvpwrvgnd_1
XTAP_307 VGND VPWR sky130_fd_sc_hd__tapvpwrvgnd_1
XFILLER_0_29_223 VGND VGND VPWR VPWR sky130_fd_sc_hd__fill_1
X_2952_ VGND VGND VPWR VPWR _2056_ _1800_ _1693_ _1414_ Mux
XFILLER_0_16_54 VGND VGND VPWR VPWR sky130_fd_sc_hd__fill_2
XFILLER_0_16_76 VGND VGND VPWR VPWR sky130_fd_sc_hd__decap_3
XFILLER_0_32_53 VGND VGND VPWR VPWR sky130_fd_sc_hd__fill_1
X_2883_ VGND VGND VPWR VPWR _1682_ _1987_ _1988_ Nor_gate
XFILLER_0_4_334 VPWR VGND VPWR VGND sky130_ef_sc_hd__decap_12
XFILLER_0_12_112 VGND VGND VPWR VPWR sky130_fd_sc_hd__decap_3
X_3366_ VGND VGND VPWR VPWR _1922_ _0320_ _0319_ Nand_gate
X_3504_ VGND VGND VPWR VPWR _0108_ _0470_ _0469_ Nand_gate
X_3435_ VGND VGND VPWR VPWR _0395_ _1985_ _1984_ _0917_ Mux
XFILLER_0_12_167 VGND VGND VPWR VPWR sky130_fd_sc_hd__fill_1
X_3297_ VGND VGND VPWR VPWR _0102_ _1914_ _0245_ Nor_gate
X_2317_ VGND VGND VPWR VPWR _1423_ _1426_ _1425_ Nand_gate
X_2179_ VGND VGND VPWR VPWR net24 _0127_ net60 Nand_gate
X_2248_ VGND VGND VPWR VPWR _0852_ _0873_ net42 Nand_gate
XFILLER_0_43_281 VPWR VGND VPWR VGND sky130_ef_sc_hd__decap_12
XFILLER_0_7_161 VGND VGND VPWR VPWR sky130_fd_sc_hd__decap_6
Xoutput89 net89 VGND VGND VPWR VPWR result[28] sky130_fd_sc_hd__clkbuf_4
Xoutput78 net78 VGND VGND VPWR VPWR result[18] sky130_fd_sc_hd__clkbuf_4
XFILLER_0_58_307 VGND VGND VPWR VPWR sky130_fd_sc_hd__fill_1
XFILLER_0_26_248 VGND VGND VPWR VPWR sky130_fd_sc_hd__fill_1
X_3220_ VGND VGND VPWR VPWR _0162_ _0014_ inverter
XTAP_148 VGND VPWR sky130_fd_sc_hd__tapvpwrvgnd_1
XTAP_137 VGND VPWR sky130_fd_sc_hd__tapvpwrvgnd_1
XFILLER_0_1_337 VGND VGND VPWR VPWR sky130_fd_sc_hd__fill_2
XTAP_126 VGND VPWR sky130_fd_sc_hd__tapvpwrvgnd_1
XTAP_159 VGND VPWR sky130_fd_sc_hd__tapvpwrvgnd_1
X_3151_ _0087_ VGND VGND VPWR VPWR net99 sky130_fd_sc_hd__buf_1
X_3082_ VGND VGND VPWR VPWR _0013_ _2074_ inverter
X_2935_ VGND VGND VPWR VPWR _1624_ _2039_ _2038_ Nand_gate
X_3984_ VGND VGND VPWR VPWR _0988_ _0933_ inverter
XFILLER_0_17_204 VGND VGND VPWR VPWR sky130_fd_sc_hd__decap_6
X_2797_ VGND VGND VPWR VPWR _1712_ _1902_ _1903_ Nor_gate
XFILLER_0_32_229 VGND VGND VPWR VPWR sky130_fd_sc_hd__decap_4
X_2866_ VGND VGND VPWR VPWR net27 _1968_ _1971_ Nor_gate
X_3418_ VGND VGND VPWR VPWR _2000_ _0377_ _0375_ Nand_gate
X_3349_ VGND VGND VPWR VPWR _1230_ _0302_ _0218_ Nand_gate
XFILLER_0_7_74 VGND VGND VPWR VPWR sky130_fd_sc_hd__decap_8
XFILLER_0_31_240 VGND VGND VPWR VPWR sky130_fd_sc_hd__decap_8
XFILLER_0_58_159 VGND VGND VPWR VPWR sky130_fd_sc_hd__decap_8
XFILLER_0_54_321 VPWR VGND VPWR VGND sky130_ef_sc_hd__decap_12
XFILLER_0_13_55 VGND VGND VPWR VPWR sky130_fd_sc_hd__fill_1
XFILLER_0_13_66 VGND VGND VPWR VPWR sky130_fd_sc_hd__decap_4
X_2720_ VGND VGND VPWR VPWR _1822_ _1827_ _1826_ Nand_gate
X_2651_ VGND VGND VPWR VPWR _1747_ _1759_ _1758_ Nand_gate
X_2582_ VGND VGND VPWR VPWR _1691_ net33 inverter
XFILLER_0_13_99 VGND VGND VPWR VPWR sky130_fd_sc_hd__fill_1
XFILLER_0_14_218 VGND VGND VPWR VPWR sky130_fd_sc_hd__decap_6
X_4321_ VGND VGND VPWR VPWR _1349_ _1351_ _1352_ Nor_gate
X_3203_ VGND VGND VPWR VPWR _1863_ _0144_ _0143_ Nand_gate
XFILLER_0_38_85 VGND VGND VPWR VPWR sky130_fd_sc_hd__decap_6
XFILLER_0_38_74 VGND VGND VPWR VPWR sky130_fd_sc_hd__decap_8
XFILLER_0_38_41 VGND VGND VPWR VPWR sky130_fd_sc_hd__decap_4
X_4252_ VGND VGND VPWR VPWR _1271_ _1278_ _1277_ Nand_gate
X_4183_ VGND VGND VPWR VPWR _1195_ _1201_ _1203_ Nor_gate
XFILLER_0_54_62 VGND VGND VPWR VPWR sky130_fd_sc_hd__decap_4
XFILLER_0_49_126 VGND VGND VPWR VPWR sky130_fd_sc_hd__fill_1
X_3134_ VGND VGND VPWR VPWR _0066_ _0068_ _0069_ Nor_gate
X_3065_ VGND VGND VPWR VPWR net30 _2167_ _2125_ Nand_gate
X_2918_ VGND VGND VPWR VPWR net95 _2022_ inverter
X_3898_ VGND VGND VPWR VPWR _0892_ _0896_ _0894_ Nand_gate
X_3967_ VGND VGND VPWR VPWR net16 _0969_ _0922_ Nand_gate
XFILLER_0_9_223 VGND VGND VPWR VPWR sky130_fd_sc_hd__fill_1
X_2849_ VGND VGND VPWR VPWR _1901_ _1955_ _1954_ Nand_gate
XFILLER_0_13_284 VGND VGND VPWR VPWR sky130_fd_sc_hd__decap_4
XFILLER_0_13_295 VGND VGND VPWR VPWR sky130_fd_sc_hd__fill_1
XFILLER_0_51_335 VGND VGND VPWR VPWR sky130_fd_sc_hd__fill_1
XFILLER_0_48_181 VGND VGND VPWR VPWR sky130_fd_sc_hd__decap_4
XFILLER_0_54_173 VGND VGND VPWR VPWR sky130_fd_sc_hd__decap_3
X_3752_ _2000_ VGND VGND VPWR VPWR _0738_ sky130_fd_sc_hd__clkbuf_4
XFILLER_0_27_321 VGND VGND VPWR VPWR sky130_fd_sc_hd__fill_1
XFILLER_0_6_237 VGND VGND VPWR VPWR sky130_fd_sc_hd__fill_1
X_3821_ VGND VGND VPWR VPWR _0813_ _0812_ inverter
XFILLER_0_54_195 VGND VGND VPWR VPWR sky130_fd_sc_hd__fill_1
X_2634_ VGND VGND VPWR VPWR _1742_ _1741_ inverter
XFILLER_0_40_75 VGND VGND VPWR VPWR sky130_fd_sc_hd__decap_3
X_2703_ VGND VGND VPWR VPWR net12 _1810_ _1779_ Nand_gate
X_2565_ VGND VGND VPWR VPWR _1649_ _1674_ _1673_ Nand_gate
X_4304_ VGND VGND VPWR VPWR _0215_ _1333_ _1332_ Nand_gate
X_3683_ VGND VGND VPWR VPWR _1491_ _0663_ _0422_ Nand_gate
X_3117_ VGND VGND VPWR VPWR _0050_ _2015_ _0049_ _1605_ Mux
XFILLER_0_49_95 VPWR VGND VPWR VGND sky130_ef_sc_hd__decap_12
X_4235_ VGND VGND VPWR VPWR _1259_ _1565_ net21 _1676_ Mux
X_2496_ _1427_ VGND VGND VPWR VPWR _1605_ sky130_fd_sc_hd__clkbuf_4
X_4166_ VGND VGND VPWR VPWR _1182_ _1184_ _1183_ Nand_gate
XFILLER_0_4_53 VPWR VGND VPWR VGND sky130_ef_sc_hd__decap_12
XFILLER_0_10_265 VGND VGND VPWR VPWR sky130_fd_sc_hd__fill_2
XFILLER_0_10_287 VGND VGND VPWR VPWR sky130_fd_sc_hd__fill_1
X_4097_ VGND VGND VPWR VPWR _1110_ _0698_ _1109_ _0135_ Mux
X_3048_ VGND VGND VPWR VPWR _2148_ _2149_ _2150_ Nor_gate
XFILLER_0_33_346 VGND VGND VPWR VPWR sky130_fd_sc_hd__fill_1
XFILLER_0_18_332 VGND VGND VPWR VPWR sky130_fd_sc_hd__fill_1
XFILLER_0_5_281 VGND VGND VPWR VPWR sky130_fd_sc_hd__decap_8
XFILLER_0_28_129 VGND VGND VPWR VPWR sky130_fd_sc_hd__decap_8
XFILLER_0_36_195 VGND VGND VPWR VPWR sky130_fd_sc_hd__fill_1
XFILLER_0_36_184 VGND VGND VPWR VPWR sky130_fd_sc_hd__fill_1
XFILLER_0_24_335 VGND VGND VPWR VPWR sky130_fd_sc_hd__decap_4
XFILLER_0_10_45 VGND VGND VPWR VPWR sky130_fd_sc_hd__fill_1
XFILLER_0_10_78 VGND VGND VPWR VPWR sky130_fd_sc_hd__decap_6
X_4020_ _1027_ VGND VGND VPWR VPWR net85 sky130_fd_sc_hd__dlymetal6s2s_1
X_2350_ VGND VGND VPWR VPWR _1459_ _1414_ inverter
XFILLER_0_19_54 VGND VGND VPWR VPWR sky130_fd_sc_hd__fill_2
XFILLER_0_19_32 VGND VGND VPWR VPWR sky130_fd_sc_hd__fill_1
X_2281_ net3 VGND VGND VPWR VPWR _1230_ sky130_fd_sc_hd__clkbuf_4
XFILLER_0_35_53 VGND VGND VPWR VPWR sky130_fd_sc_hd__decap_3
XFILLER_0_35_31 VGND VGND VPWR VPWR sky130_fd_sc_hd__decap_6
XFILLER_0_42_132 VGND VGND VPWR VPWR sky130_fd_sc_hd__fill_1
X_3804_ VGND VGND VPWR VPWR _0228_ _0794_ _0592_ Nand_gate
X_3735_ VGND VGND VPWR VPWR _0718_ _0675_ _0719_ Nor_gate
XFILLER_0_15_324 VPWR VGND VPWR VGND sky130_ef_sc_hd__decap_12
X_2548_ VGND VGND VPWR VPWR _1657_ net15 inverter
X_2617_ VGND VGND VPWR VPWR _1718_ _1725_ _1724_ Nand_gate
XFILLER_0_42_176 VGND VGND VPWR VPWR sky130_fd_sc_hd__decap_8
XFILLER_0_2_251 VGND VGND VPWR VPWR sky130_fd_sc_hd__fill_1
X_3597_ VGND VGND VPWR VPWR _0269_ _0570_ _0569_ Nand_gate
X_3666_ VGND VGND VPWR VPWR _0645_ _0644_ inverter
X_2479_ net48 VGND VGND VPWR VPWR _1588_ sky130_fd_sc_hd__clkbuf_4
X_4149_ VGND VGND VPWR VPWR _1167_ net56 inverter
X_4218_ VGND VGND VPWR VPWR net57 _1241_ _0215_ Nand_gate
XFILLER_0_33_154 VGND VGND VPWR VPWR sky130_fd_sc_hd__fill_1
XFILLER_0_21_305 VPWR VGND VPWR VGND sky130_ef_sc_hd__decap_12
XFILLER_0_18_184 VGND VGND VPWR VPWR sky130_fd_sc_hd__fill_2
XFILLER_0_56_246 VGND VGND VPWR VPWR sky130_fd_sc_hd__decap_6
XFILLER_0_24_132 VGND VGND VPWR VPWR sky130_fd_sc_hd__decap_8
XFILLER_0_24_121 VGND VGND VPWR VPWR sky130_fd_sc_hd__decap_8
XFILLER_0_21_44 VPWR VGND VPWR VGND sky130_ef_sc_hd__decap_12
XFILLER_0_21_11 VGND VGND VPWR VPWR sky130_fd_sc_hd__fill_1
X_3520_ VGND VGND VPWR VPWR _0481_ _0485_ _0487_ Nor_gate
X_2333_ VGND VGND VPWR VPWR _1439_ _1442_ _1441_ Nand_gate
X_3451_ VGND VGND VPWR VPWR _0373_ _0413_ _0412_ Nand_gate
X_3382_ VGND VGND VPWR VPWR net2 _0338_ net3 Nand_gate
X_2402_ VGND VGND VPWR VPWR _0679_ net46 _1511_ Nor_gate
XFILLER_0_46_85 VGND VGND VPWR VPWR sky130_fd_sc_hd__fill_1
X_2195_ VGND VGND VPWR VPWR _0278_ _0300_ _0289_ Nand_gate
X_4003_ VGND VGND VPWR VPWR _0108_ _0065_ _1009_ Nor_gate
XFILLER_0_27_6 VGND VGND VPWR VPWR sky130_fd_sc_hd__decap_6
X_2264_ VGND VGND VPWR VPWR _1014_ net43 _1046_ Nor_gate
XFILLER_0_7_321 VGND VGND VPWR VPWR sky130_fd_sc_hd__fill_1
X_3649_ VGND VGND VPWR VPWR _0627_ _0501_ _0626_ _1938_ Mux
X_3718_ VGND VGND VPWR VPWR _0594_ _0702_ _0700_ Nand_gate
XFILLER_0_30_179 VGND VGND VPWR VPWR sky130_fd_sc_hd__fill_1
XFILLER_0_38_213 VGND VGND VPWR VPWR sky130_fd_sc_hd__decap_8
XTAP_319 VGND VPWR sky130_fd_sc_hd__tapvpwrvgnd_1
XTAP_308 VGND VPWR sky130_fd_sc_hd__tapvpwrvgnd_1
XFILLER_0_21_179 VGND VGND VPWR VPWR sky130_fd_sc_hd__decap_8
XFILLER_0_21_113 VGND VGND VPWR VPWR sky130_fd_sc_hd__fill_2
XFILLER_0_32_43 VGND VGND VPWR VPWR sky130_fd_sc_hd__fill_1
XFILLER_0_32_21 VGND VGND VPWR VPWR sky130_fd_sc_hd__decap_3
X_2951_ VGND VGND VPWR VPWR _1700_ _2055_ _2054_ Nand_gate
XFILLER_0_52_271 VGND VGND VPWR VPWR sky130_fd_sc_hd__decap_8
XFILLER_0_44_249 VGND VGND VPWR VPWR sky130_fd_sc_hd__decap_3
XFILLER_0_44_238 VGND VGND VPWR VPWR sky130_fd_sc_hd__fill_2
X_2882_ VGND VGND VPWR VPWR _1987_ _1984_ _1985_ _1986_ Mux
X_3503_ VGND VGND VPWR VPWR _1922_ _0469_ _0468_ Nand_gate
XFILLER_0_4_346 VGND VGND VPWR VPWR sky130_fd_sc_hd__fill_1
X_3296_ VGND VGND VPWR VPWR _0244_ _1904_ inverter
X_2316_ VGND VGND VPWR VPWR _1424_ _1425_ _1421_ Nand_gate
X_3365_ VGND VGND VPWR VPWR _0314_ _0319_ _0318_ Nand_gate
X_3434_ VGND VGND VPWR VPWR net41 _0394_ _0393_ Nand_gate
X_2178_ VGND VGND VPWR VPWR _0094_ _0116_ _0105_ Nand_gate
X_2247_ VGND VGND VPWR VPWR _0852_ net42 _0863_ Nor_gate
XFILLER_0_7_184 VGND VGND VPWR VPWR sky130_fd_sc_hd__fill_1
XFILLER_0_50_219 VGND VGND VPWR VPWR sky130_fd_sc_hd__decap_4
XFILLER_0_43_293 VPWR VGND VPWR VGND sky130_ef_sc_hd__decap_12
Xoutput79 net79 VGND VGND VPWR VPWR result[19] sky130_fd_sc_hd__clkbuf_4
XTAP_149 VGND VPWR sky130_fd_sc_hd__tapvpwrvgnd_1
XTAP_138 VGND VPWR sky130_fd_sc_hd__tapvpwrvgnd_1
XTAP_127 VGND VPWR sky130_fd_sc_hd__tapvpwrvgnd_1
X_3150_ VGND VGND VPWR VPWR _0045_ _0087_ _0086_ Nand_gate
XFILLER_0_27_21 VPWR VGND VPWR VGND sky130_ef_sc_hd__decap_12
X_3081_ VGND VGND VPWR VPWR net98 _0012_ inverter
XFILLER_0_43_97 VGND VGND VPWR VPWR sky130_fd_sc_hd__decap_3
X_2934_ VGND VGND VPWR VPWR _1633_ _2037_ _2038_ Nor_gate
X_3983_ VGND VGND VPWR VPWR _0984_ _0987_ _0986_ Nand_gate
X_2865_ VGND VGND VPWR VPWR _1970_ _1969_ inverter
XFILLER_0_40_263 VGND VGND VPWR VPWR sky130_fd_sc_hd__decap_3
X_2796_ VGND VGND VPWR VPWR _1902_ _1749_ _1751_ _1588_ Mux
XFILLER_0_25_271 VGND VGND VPWR VPWR sky130_fd_sc_hd__fill_2
XFILLER_0_7_86 VGND VGND VPWR VPWR sky130_fd_sc_hd__decap_4
X_3417_ VGND VGND VPWR VPWR _0102_ _0375_ _2032_ Nand_gate
X_3348_ VGND VGND VPWR VPWR _1230_ _0218_ _0301_ Nor_gate
X_3279_ VGND VGND VPWR VPWR _0222_ _0225_ _0226_ Nor_gate
XFILLER_0_16_271 VPWR VGND VPWR VGND sky130_ef_sc_hd__decap_12
XFILLER_0_54_333 VGND VGND VPWR VPWR sky130_fd_sc_hd__decap_8
XFILLER_0_13_89 VGND VGND VPWR VPWR sky130_fd_sc_hd__decap_3
X_4320_ VGND VGND VPWR VPWR _0594_ _1351_ _1350_ Nand_gate
X_2650_ VGND VGND VPWR VPWR _1671_ _1758_ _1757_ Nand_gate
X_2581_ _1689_ VGND VGND VPWR VPWR _1690_ sky130_fd_sc_hd__clkbuf_4
XFILLER_0_1_113 VPWR VGND VPWR VGND sky130_ef_sc_hd__decap_12
X_3202_ VGND VGND VPWR VPWR _0140_ _0143_ _0142_ Nand_gate
X_3133_ VGND VGND VPWR VPWR _1650_ _0068_ _0067_ Nand_gate
X_4182_ VGND VGND VPWR VPWR _1195_ _1202_ _1201_ Nand_gate
X_4251_ VGND VGND VPWR VPWR _1275_ _1276_ _1277_ Nor_gate
XFILLER_0_54_41 VPWR VGND VPWR VGND sky130_ef_sc_hd__decap_12
X_3064_ VGND VGND VPWR VPWR _2153_ _2165_ _2166_ Nor_gate
XFILLER_0_57_193 VGND VGND VPWR VPWR sky130_fd_sc_hd__fill_1
XFILLER_0_45_311 VPWR VGND VPWR VGND sky130_ef_sc_hd__decap_12
X_2848_ VGND VGND VPWR VPWR _1935_ _1953_ _1954_ Nor_gate
X_2917_ VGND VGND VPWR VPWR _1976_ _2021_ _2022_ Nor_gate
X_3966_ VGND VGND VPWR VPWR _0968_ _0967_ inverter
XFILLER_0_9_246 VGND VGND VPWR VPWR sky130_fd_sc_hd__fill_1
XFILLER_0_9_279 VGND VGND VPWR VPWR sky130_fd_sc_hd__fill_1
X_3897_ VGND VGND VPWR VPWR _0370_ _0893_ _0894_ Nor_gate
X_2779_ VGND VGND VPWR VPWR _1859_ _1885_ _1886_ Nor_gate
XTAP_480 VGND VPWR sky130_fd_sc_hd__tapvpwrvgnd_1
XFILLER_0_24_66 VGND VGND VPWR VPWR sky130_fd_sc_hd__fill_2
XFILLER_0_24_55 VGND VGND VPWR VPWR sky130_fd_sc_hd__fill_2
XFILLER_0_54_141 VPWR VGND VPWR VGND sky130_ef_sc_hd__decap_12
X_3751_ VGND VGND VPWR VPWR _0737_ _0253_ _0736_ _0135_ Mux
XFILLER_0_40_54 VGND VGND VPWR VPWR sky130_fd_sc_hd__decap_4
XFILLER_0_24_99 VGND VGND VPWR VPWR sky130_fd_sc_hd__fill_2
XFILLER_0_24_77 VGND VGND VPWR VPWR sky130_fd_sc_hd__fill_1
X_2702_ VGND VGND VPWR VPWR net80 _1809_ inverter
X_3682_ VGND VGND VPWR VPWR _0424_ _0662_ _0360_ Nand_gate
X_3820_ VGND VGND VPWR VPWR _0463_ _0811_ _0812_ Nor_gate
X_2633_ VGND VGND VPWR VPWR _1741_ net14 net15 net37 Mux
X_2564_ VGND VGND VPWR VPWR _1650_ _1673_ _1672_ Nand_gate
X_4303_ VGND VGND VPWR VPWR _0105_ _1332_ _1286_ Nand_gate
X_2495_ VGND VGND VPWR VPWR _1581_ _1604_ _1603_ Nand_gate
X_4096_ VGND VGND VPWR VPWR _1109_ _0899_ _1108_ _0379_ Mux
X_3116_ VGND VGND VPWR VPWR _0049_ _0046_ _0048_ _1938_ Mux
X_4165_ VGND VGND VPWR VPWR _1083_ _1138_ _1183_ Nor_gate
X_4234_ VGND VGND VPWR VPWR _1255_ _1258_ _1257_ Nand_gate
XFILLER_0_4_65 VPWR VGND VPWR VGND sky130_ef_sc_hd__decap_12
XFILLER_0_4_21 VGND VGND VPWR VPWR sky130_fd_sc_hd__decap_6
X_3047_ VGND VGND VPWR VPWR _1765_ _1890_ _2149_ Nor_gate
XFILLER_0_18_344 VGND VGND VPWR VPWR sky130_fd_sc_hd__decap_3
XFILLER_0_18_322 VGND VGND VPWR VPWR sky130_fd_sc_hd__fill_1
X_3949_ VGND VGND VPWR VPWR _0951_ _0512_ _0513_ _0506_ Mux
XFILLER_0_51_111 VGND VGND VPWR VPWR sky130_fd_sc_hd__fill_1
XFILLER_0_36_130 VGND VGND VPWR VPWR sky130_fd_sc_hd__fill_1
XFILLER_0_51_166 VGND VGND VPWR VPWR sky130_fd_sc_hd__fill_2
XFILLER_0_35_21 VGND VGND VPWR VPWR sky130_fd_sc_hd__decap_6
X_2280_ VGND VGND VPWR VPWR _1186_ _1208_ _1219_ Nor_gate
XFILLER_0_51_31 VPWR VGND VPWR VGND sky130_ef_sc_hd__decap_12
XFILLER_0_35_98 VGND VGND VPWR VPWR sky130_fd_sc_hd__fill_1
X_3803_ VGND VGND VPWR VPWR _0790_ _0793_ _0792_ Nand_gate
X_2616_ VGND VGND VPWR VPWR _1671_ _1723_ _1724_ Nor_gate
XFILLER_0_42_100 VPWR VGND VPWR VGND sky130_ef_sc_hd__decap_12
XFILLER_0_27_130 VGND VGND VPWR VPWR sky130_fd_sc_hd__fill_1
X_3734_ VGND VGND VPWR VPWR _0647_ _0654_ _0718_ Nor_gate
X_3665_ VGND VGND VPWR VPWR _0640_ _0643_ _0644_ Nor_gate
X_2478_ VGND VGND VPWR VPWR _1435_ _1586_ _1587_ Nor_gate
X_4217_ _1239_ VGND VGND VPWR VPWR net89 sky130_fd_sc_hd__clkbuf_2
X_3596_ VGND VGND VPWR VPWR _0787_ _0569_ _0567_ Nand_gate
X_2547_ VGND VGND VPWR VPWR _1656_ _1533_ _1655_ _1615_ Mux
X_4148_ VGND VGND VPWR VPWR net20 net56 _1166_ Nor_gate
X_4079_ VGND VGND VPWR VPWR _0876_ _1091_ _1087_ Nand_gate
XFILLER_0_18_141 VGND VGND VPWR VPWR sky130_fd_sc_hd__decap_6
XFILLER_0_33_188 VGND VGND VPWR VPWR sky130_fd_sc_hd__decap_3
XFILLER_0_33_177 VGND VGND VPWR VPWR sky130_fd_sc_hd__fill_1
X_2332_ VGND VGND VPWR VPWR net1 _1441_ _1440_ Nand_gate
X_3450_ VGND VGND VPWR VPWR _0385_ _0411_ _0412_ Nor_gate
X_3381_ VGND VGND VPWR VPWR _0320_ _0337_ _0336_ Nand_gate
X_2401_ VGND VGND VPWR VPWR _0679_ _0657_ _1510_ Nor_gate
X_4002_ VGND VGND VPWR VPWR _0996_ _1008_ _1007_ Nand_gate
X_2194_ VPWR VGND VGND VPWR net20 _0289_ net56 Xnor
X_2263_ VGND VGND VPWR VPWR _1035_ _1025_ inverter
XFILLER_0_47_269 VGND VGND VPWR VPWR sky130_fd_sc_hd__decap_8
XFILLER_0_47_225 VPWR VGND VPWR VGND sky130_ef_sc_hd__decap_12
XFILLER_0_15_111 VGND VGND VPWR VPWR sky130_fd_sc_hd__fill_1
X_3648_ VGND VGND VPWR VPWR _0626_ _0733_ _0787_ _1608_ Mux
X_3717_ VGND VGND VPWR VPWR _0700_ _1868_ _0699_ _2000_ Mux
XFILLER_0_30_169 VGND VGND VPWR VPWR sky130_fd_sc_hd__fill_1
X_3579_ VGND VGND VPWR VPWR _0541_ _0550_ _0551_ Nor_gate
XTAP_309 VGND VPWR sky130_fd_sc_hd__tapvpwrvgnd_1
XFILLER_0_21_169 VGND VGND VPWR VPWR sky130_fd_sc_hd__decap_4
XFILLER_0_44_228 VGND VGND VPWR VPWR sky130_fd_sc_hd__fill_1
X_2950_ VGND VGND VPWR VPWR _2049_ _2054_ _2053_ Nand_gate
XFILLER_0_32_11 VGND VGND VPWR VPWR sky130_fd_sc_hd__fill_1
XFILLER_0_29_225 VGND VGND VPWR VPWR sky130_fd_sc_hd__fill_2
X_2881_ VGND VGND VPWR VPWR _1700_ _1461_ _1986_ Nor_gate
X_3502_ VGND VGND VPWR VPWR _1637_ _1843_ _0468_ Nor_gate
X_3433_ _2002_ VGND VGND VPWR VPWR _0393_ sky130_fd_sc_hd__clkbuf_4
XFILLER_0_57_52 VGND VGND VPWR VPWR sky130_fd_sc_hd__decap_4
X_2246_ net6 VGND VGND VPWR VPWR _0852_ sky130_fd_sc_hd__clkbuf_4
X_3364_ VGND VGND VPWR VPWR _0315_ _0318_ _0317_ Nand_gate
X_2315_ VGND VGND VPWR VPWR _1424_ net62 inverter
X_3295_ VGND VGND VPWR VPWR _0230_ _0242_ _0243_ Nor_gate
X_2177_ VGND VGND VPWR VPWR _0105_ net60 inverter
XFILLER_0_18_3 VGND VGND VPWR VPWR sky130_fd_sc_hd__decap_4
XFILLER_0_43_261 VPWR VGND VPWR VGND sky130_ef_sc_hd__decap_12
XFILLER_0_35_217 VGND VGND VPWR VPWR sky130_fd_sc_hd__decap_6
XFILLER_0_35_206 VGND VGND VPWR VPWR sky130_fd_sc_hd__decap_8
Xoutput69 net69 VGND VGND VPWR VPWR result[0] sky130_fd_sc_hd__clkbuf_4
XFILLER_0_58_309 VGND VGND VPWR VPWR sky130_fd_sc_hd__fill_2
XFILLER_0_27_33 VGND VGND VPWR VPWR sky130_fd_sc_hd__fill_2
XTAP_139 VGND VPWR sky130_fd_sc_hd__tapvpwrvgnd_1
XTAP_128 VGND VPWR sky130_fd_sc_hd__tapvpwrvgnd_1
X_3080_ VGND VGND VPWR VPWR _2144_ _0011_ _0012_ Nor_gate
X_3982_ VGND VGND VPWR VPWR _0042_ _0985_ _0986_ Nor_gate
XFILLER_0_27_77 VPWR VGND VPWR VGND sky130_ef_sc_hd__decap_12
XPHY_0 VGND VGND VPWR VPWR sky130_fd_sc_hd__decap_3
XFILLER_0_43_76 VGND VGND VPWR VPWR sky130_fd_sc_hd__decap_6
X_2933_ VGND VGND VPWR VPWR _2037_ _1770_ inverter
X_2795_ VGND VGND VPWR VPWR _1897_ _1901_ _1900_ Nand_gate
X_2864_ VGND VGND VPWR VPWR net27 _1969_ _1968_ Nand_gate
X_3416_ VGND VGND VPWR VPWR _0102_ _2051_ _0374_ Nor_gate
XFILLER_0_40_275 VGND VGND VPWR VPWR sky130_fd_sc_hd__decap_4
XFILLER_0_40_253 VGND VGND VPWR VPWR sky130_fd_sc_hd__fill_1
XFILLER_0_4_155 VGND VGND VPWR VPWR sky130_fd_sc_hd__decap_8
X_3347_ VGND VGND VPWR VPWR _0298_ _0292_ _0299_ Nor_gate
X_3278_ VGND VGND VPWR VPWR _1690_ _0225_ _0223_ Nand_gate
X_2229_ VGND VGND VPWR VPWR _0647_ _0668_ _0657_ Nand_gate
XFILLER_0_23_209 VPWR VGND VPWR VGND sky130_ef_sc_hd__decap_12
XFILLER_0_16_283 VPWR VGND VPWR VGND sky130_ef_sc_hd__decap_12
XFILLER_0_7_3 VPWR VGND VPWR VGND sky130_ef_sc_hd__decap_12
XFILLER_0_58_139 VGND VGND VPWR VPWR sky130_fd_sc_hd__fill_1
XFILLER_0_13_57 VGND VGND VPWR VPWR sky130_fd_sc_hd__decap_6
X_2580_ VGND VGND VPWR VPWR _1678_ _1680_ _1689_ Nor_gate
X_4250_ VGND VGND VPWR VPWR _0181_ _0001_ _1276_ Nor_gate
XFILLER_0_1_125 VPWR VGND VPWR VGND sky130_ef_sc_hd__decap_12
XFILLER_0_1_169 VPWR VGND VPWR VGND sky130_ef_sc_hd__decap_12
X_3201_ VGND VGND VPWR VPWR _1797_ _0142_ _0141_ Nand_gate
X_3063_ VGND VGND VPWR VPWR _2159_ _2164_ _2165_ Nor_gate
X_3132_ VGND VGND VPWR VPWR _1922_ _0067_ _0064_ Nand_gate
X_4181_ VGND VGND VPWR VPWR _1201_ _1200_ inverter
X_3965_ VGND VGND VPWR VPWR net16 _0922_ _0967_ Nor_gate
XFILLER_0_9_225 VGND VGND VPWR VPWR sky130_fd_sc_hd__decap_8
XFILLER_0_45_345 VGND VGND VPWR VPWR sky130_fd_sc_hd__fill_2
XFILLER_0_45_323 VPWR VGND VPWR VGND sky130_ef_sc_hd__decap_12
X_2778_ VGND VGND VPWR VPWR _1869_ _1885_ _1884_ Nand_gate
X_2847_ VGND VGND VPWR VPWR _1941_ _1953_ _1952_ Nand_gate
X_2916_ VGND VGND VPWR VPWR _1990_ _2021_ _2020_ Nand_gate
X_3896_ VGND VGND VPWR VPWR _0333_ _0891_ _0893_ Nor_gate
XFILLER_0_13_264 VPWR VGND VPWR VGND sky130_ef_sc_hd__decap_12
XTAP_481 VGND VPWR sky130_fd_sc_hd__tapvpwrvgnd_1
XTAP_470 VGND VPWR sky130_fd_sc_hd__tapvpwrvgnd_1
XFILLER_0_55_109 VGND VGND VPWR VPWR sky130_fd_sc_hd__decap_3
XFILLER_0_51_337 VGND VGND VPWR VPWR sky130_fd_sc_hd__decap_6
XFILLER_0_51_315 VPWR VGND VPWR VGND sky130_ef_sc_hd__decap_12
XFILLER_0_39_161 VGND VGND VPWR VPWR sky130_fd_sc_hd__decap_3
XFILLER_0_24_45 VGND VGND VPWR VPWR sky130_fd_sc_hd__fill_1
X_3750_ VGND VGND VPWR VPWR _0736_ _0502_ _0735_ _0379_ Mux
XFILLER_0_54_153 VPWR VGND VPWR VGND sky130_ef_sc_hd__decap_12
X_2632_ VGND VGND VPWR VPWR _1740_ _1739_ inverter
XFILLER_0_39_172 VPWR VGND VPWR VGND sky130_ef_sc_hd__decap_12
XFILLER_0_40_33 VGND VGND VPWR VPWR sky130_fd_sc_hd__fill_1
X_2701_ VGND VGND VPWR VPWR _1763_ _1808_ _1809_ Nor_gate
X_3681_ VGND VGND VPWR VPWR _0660_ _0661_ _0534_ Nand_gate
X_2563_ VGND VGND VPWR VPWR _1672_ _1661_ _1670_ _1671_ Mux
X_4233_ VGND VGND VPWR VPWR _0370_ _1256_ _1257_ Nor_gate
X_4302_ VGND VGND VPWR VPWR _1330_ _1331_ _1293_ Nand_gate
X_2494_ VGND VGND VPWR VPWR _1582_ _1602_ _1603_ Nor_gate
X_3115_ VGND VGND VPWR VPWR _0048_ _0047_ inverter
X_4095_ VGND VGND VPWR VPWR _1108_ _1000_ _1107_ _0255_ Mux
X_3046_ VGND VGND VPWR VPWR _1624_ _2148_ _2147_ Nand_gate
X_4164_ VGND VGND VPWR VPWR _1180_ _1181_ _1182_ Nor_gate
XFILLER_0_4_99 VGND VGND VPWR VPWR sky130_fd_sc_hd__decap_8
XFILLER_0_4_77 VGND VGND VPWR VPWR sky130_fd_sc_hd__decap_6
X_3948_ VGND VGND VPWR VPWR net52 _0950_ _0393_ Nand_gate
XFILLER_0_33_315 VGND VGND VPWR VPWR sky130_fd_sc_hd__fill_1
X_3879_ VGND VGND VPWR VPWR _0875_ _0780_ inverter
XFILLER_0_51_134 VPWR VGND VPWR VGND sky130_ef_sc_hd__decap_12
XFILLER_0_51_101 VGND VGND VPWR VPWR sky130_fd_sc_hd__decap_3
XFILLER_0_35_66 VGND VGND VPWR VPWR sky130_fd_sc_hd__decap_4
XFILLER_0_19_67 VGND VGND VPWR VPWR sky130_fd_sc_hd__fill_1
XFILLER_0_51_65 VGND VGND VPWR VPWR sky130_fd_sc_hd__fill_1
XFILLER_0_51_43 VPWR VGND VPWR VGND sky130_ef_sc_hd__decap_12
XFILLER_0_27_153 VGND VGND VPWR VPWR sky130_fd_sc_hd__fill_1
X_3802_ VGND VGND VPWR VPWR _0370_ _0791_ _0792_ Nor_gate
X_2615_ VGND VGND VPWR VPWR _1713_ _1722_ _1723_ Nor_gate
XFILLER_0_30_307 VGND VGND VPWR VPWR sky130_fd_sc_hd__fill_1
XFILLER_0_27_197 VGND VGND VPWR VPWR sky130_fd_sc_hd__decap_6
XFILLER_0_27_186 VGND VGND VPWR VPWR sky130_fd_sc_hd__decap_8
X_3664_ VGND VGND VPWR VPWR _0641_ _0643_ _0642_ Nand_gate
XFILLER_0_2_253 VPWR VGND VPWR VGND sky130_ef_sc_hd__decap_12
X_3733_ VPWR VGND VGND VPWR _0582_ _0717_ _0716_ Xnor
X_3595_ VGND VGND VPWR VPWR _0787_ _0567_ _0568_ Nor_gate
XFILLER_0_15_337 VGND VGND VPWR VPWR sky130_fd_sc_hd__decap_8
XFILLER_0_48_3 VPWR VGND VPWR VGND sky130_ef_sc_hd__decap_12
X_2477_ VGND VGND VPWR VPWR _1585_ net1 _1586_ Nor_gate
X_4147_ VGND VGND VPWR VPWR net56 _1164_ _0393_ Nand_gate
X_4216_ VGND VGND VPWR VPWR _1205_ _1239_ _1238_ Nand_gate
X_2546_ VGND VGND VPWR VPWR _1655_ _0387_ inverter
X_3029_ VGND VGND VPWR VPWR _2105_ _2131_ _2132_ Nor_gate
X_4078_ VGND VGND VPWR VPWR _0671_ _1088_ _1090_ Nor_gate
XFILLER_0_33_101 VGND VGND VPWR VPWR sky130_fd_sc_hd__decap_8
XFILLER_0_18_197 VGND VGND VPWR VPWR sky130_fd_sc_hd__decap_6
XFILLER_0_33_167 VGND VGND VPWR VPWR sky130_fd_sc_hd__fill_1
XFILLER_0_21_68 VGND VGND VPWR VPWR sky130_fd_sc_hd__decap_3
XFILLER_0_12_318 VGND VGND VPWR VPWR sky130_fd_sc_hd__fill_2
X_2400_ VGND VGND VPWR VPWR _1507_ _1508_ _1509_ Nor_gate
X_4001_ VGND VGND VPWR VPWR _0999_ _1007_ _1006_ Nand_gate
XFILLER_0_46_21 VGND VGND VPWR VPWR sky130_fd_sc_hd__decap_6
X_2331_ VGND VGND VPWR VPWR net37 net48 _1440_ Nor_gate
X_3380_ VGND VGND VPWR VPWR _0327_ _0335_ _0336_ Nor_gate
X_2262_ VGND VGND VPWR VPWR _1014_ _1025_ net43 Nand_gate
X_2193_ VPWR VGND VGND VPWR net19 _0278_ net55 Xnor
XFILLER_0_1_45 VGND VGND VPWR VPWR sky130_fd_sc_hd__decap_4
XFILLER_0_55_281 VGND VGND VPWR VPWR sky130_fd_sc_hd__fill_2
X_3716_ VGND VGND VPWR VPWR _0699_ _0198_ _0698_ _1614_ Mux
XFILLER_0_47_237 VPWR VGND VPWR VGND sky130_ef_sc_hd__decap_12
XFILLER_0_7_345 VGND VGND VPWR VPWR sky130_fd_sc_hd__fill_2
XFILLER_0_15_134 VGND VGND VPWR VPWR sky130_fd_sc_hd__decap_8
X_2529_ VGND VGND VPWR VPWR _1441_ _1637_ _1638_ Nor_gate
X_3647_ VGND VGND VPWR VPWR _0622_ _0624_ _0623_ Nand_gate
X_3578_ VGND VGND VPWR VPWR _0542_ _0550_ _0548_ Nand_gate
XFILLER_0_15_167 VGND VGND VPWR VPWR sky130_fd_sc_hd__fill_1
XFILLER_0_16_68 VGND VGND VPWR VPWR sky130_fd_sc_hd__decap_8
XFILLER_0_37_281 VPWR VGND VPWR VGND sky130_ef_sc_hd__decap_12
XFILLER_0_29_215 VGND VGND VPWR VPWR sky130_fd_sc_hd__fill_1
X_2880_ _1800_ VGND VGND VPWR VPWR _1985_ sky130_fd_sc_hd__buf_2
XFILLER_0_4_315 VGND VGND VPWR VPWR sky130_fd_sc_hd__fill_1
XFILLER_0_52_251 VGND VGND VPWR VPWR sky130_fd_sc_hd__fill_1
X_3363_ VGND VGND VPWR VPWR _1636_ _0316_ _0317_ Nor_gate
X_3501_ VGND VGND VPWR VPWR _1644_ _0466_ _0467_ Nor_gate
X_3432_ VGND VGND VPWR VPWR _1922_ _0392_ _0391_ Nand_gate
XFILLER_0_57_97 VGND VGND VPWR VPWR sky130_fd_sc_hd__fill_1
X_2176_ VGND VGND VPWR VPWR _0094_ net24 inverter
X_2314_ VGND VGND VPWR VPWR net62 _1423_ _1420_ Nand_gate
X_3294_ VGND VGND VPWR VPWR _2000_ _0242_ _0227_ Nand_gate
X_2245_ VGND VGND VPWR VPWR _0322_ _0830_ _0841_ Nor_gate
XFILLER_0_43_273 VGND VGND VPWR VPWR sky130_fd_sc_hd__decap_6
XFILLER_0_43_240 VGND VGND VPWR VPWR sky130_fd_sc_hd__decap_8
XPHY_110 VGND VGND VPWR VPWR sky130_fd_sc_hd__decap_3
XFILLER_0_19_281 VGND VGND VPWR VPWR sky130_fd_sc_hd__decap_6
XFILLER_0_34_284 VGND VGND VPWR VPWR sky130_fd_sc_hd__fill_1
XFILLER_0_34_262 VGND VGND VPWR VPWR sky130_fd_sc_hd__decap_3
XFILLER_0_34_251 VGND VGND VPWR VPWR sky130_fd_sc_hd__fill_1
XFILLER_0_34_240 VGND VGND VPWR VPWR sky130_fd_sc_hd__fill_2
XFILLER_0_27_67 VGND VGND VPWR VPWR sky130_fd_sc_hd__fill_1
XTAP_129 VGND VPWR sky130_fd_sc_hd__tapvpwrvgnd_1
XTAP_118 VGND VPWR sky130_fd_sc_hd__tapvpwrvgnd_1
XFILLER_0_43_66 VGND VGND VPWR VPWR sky130_fd_sc_hd__fill_1
X_2932_ VGND VGND VPWR VPWR _1648_ _2035_ _2036_ Nor_gate
X_3981_ VGND VGND VPWR VPWR _0975_ _0983_ _0985_ Nor_gate
XPHY_1 VGND VGND VPWR VPWR sky130_fd_sc_hd__decap_3
X_2794_ VGND VGND VPWR VPWR _1898_ _1899_ _1900_ Nor_gate
X_2863_ VPWR VGND VGND VPWR net63 _1968_ _1967_ Xnor
XFILLER_0_40_221 VPWR VGND VPWR VGND sky130_ef_sc_hd__decap_12
XFILLER_0_7_55 VGND VGND VPWR VPWR sky130_fd_sc_hd__fill_1
X_3346_ VGND VGND VPWR VPWR _0295_ _0298_ _0297_ Nand_gate
XFILLER_0_7_66 VGND VGND VPWR VPWR sky130_fd_sc_hd__fill_1
X_3415_ VGND VGND VPWR VPWR _0369_ _0373_ _0372_ Nand_gate
X_3277_ VGND VGND VPWR VPWR _0219_ _0223_ _0221_ Nand_gate
X_2228_ VGND VGND VPWR VPWR _0657_ net46 inverter
XFILLER_0_48_321 VPWR VGND VPWR VGND sky130_ef_sc_hd__decap_12
XFILLER_0_31_254 VGND VGND VPWR VPWR sky130_fd_sc_hd__decap_8
XFILLER_0_16_251 VGND VGND VPWR VPWR sky130_fd_sc_hd__fill_1
XFILLER_0_16_295 VPWR VGND VPWR VGND sky130_ef_sc_hd__decap_12
XFILLER_0_58_107 VGND VGND VPWR VPWR sky130_fd_sc_hd__decap_4
XFILLER_0_13_47 VGND VGND VPWR VPWR sky130_fd_sc_hd__fill_2
XFILLER_0_38_11 VPWR VGND VPWR VGND sky130_ef_sc_hd__decap_12
X_3200_ VGND VGND VPWR VPWR _1713_ _1424_ _0141_ Nor_gate
X_4180_ VPWR VGND VGND VPWR net21 _1200_ _1199_ Xnor
XFILLER_0_22_243 VGND VGND VPWR VPWR sky130_fd_sc_hd__fill_1
XFILLER_0_22_232 VGND VGND VPWR VPWR sky130_fd_sc_hd__decap_4
XFILLER_0_22_221 VGND VGND VPWR VPWR sky130_fd_sc_hd__decap_4
XFILLER_0_1_137 VPWR VGND VPWR VGND sky130_ef_sc_hd__decap_12
X_3062_ VGND VGND VPWR VPWR _1924_ _2163_ _2164_ Nor_gate
X_3131_ VGND VGND VPWR VPWR _1644_ _0065_ _0066_ Nor_gate
XFILLER_0_49_107 VGND VGND VPWR VPWR sky130_fd_sc_hd__decap_4
XFILLER_0_45_335 VGND VGND VPWR VPWR sky130_fd_sc_hd__fill_1
X_2915_ VGND VGND VPWR VPWR _2004_ _2020_ _2019_ Nand_gate
X_3895_ VGND VGND VPWR VPWR _0333_ _0892_ _0891_ Nand_gate
X_3964_ VGND VGND VPWR VPWR _0872_ _0966_ _0961_ Nand_gate
XFILLER_0_9_204 VPWR VGND VPWR VGND sky130_ef_sc_hd__decap_12
XFILLER_0_9_259 VPWR VGND VPWR VGND sky130_ef_sc_hd__decap_12
X_2777_ VGND VGND VPWR VPWR _1871_ _1883_ _1884_ Nor_gate
X_2846_ VGND VGND VPWR VPWR _1942_ _1951_ _1952_ Nor_gate
XFILLER_0_13_243 VPWR VGND VPWR VGND sky130_ef_sc_hd__decap_12
XFILLER_0_13_276 VGND VGND VPWR VPWR sky130_fd_sc_hd__decap_4
XTAP_482 VGND VPWR sky130_fd_sc_hd__tapvpwrvgnd_1
XTAP_471 VGND VPWR sky130_fd_sc_hd__tapvpwrvgnd_1
XTAP_460 VGND VPWR sky130_fd_sc_hd__tapvpwrvgnd_1
X_3329_ VGND VGND VPWR VPWR _0152_ _0280_ _0279_ Nand_gate
XFILLER_0_51_327 VGND VGND VPWR VPWR sky130_fd_sc_hd__decap_8
XFILLER_0_48_195 VGND VGND VPWR VPWR sky130_fd_sc_hd__fill_1
XFILLER_0_48_162 VGND VGND VPWR VPWR sky130_fd_sc_hd__fill_1
XFILLER_0_36_335 VGND VGND VPWR VPWR sky130_fd_sc_hd__fill_1
XFILLER_0_54_121 VGND VGND VPWR VPWR sky130_fd_sc_hd__decap_8
XFILLER_0_54_110 VGND VGND VPWR VPWR sky130_fd_sc_hd__fill_2
XFILLER_0_39_184 VPWR VGND VPWR VGND sky130_ef_sc_hd__decap_12
XFILLER_0_39_140 VGND VGND VPWR VPWR sky130_fd_sc_hd__decap_4
XFILLER_0_27_335 VGND VGND VPWR VPWR sky130_fd_sc_hd__fill_1
XFILLER_0_24_13 VPWR VGND VPWR VGND sky130_ef_sc_hd__decap_12
XFILLER_0_54_165 VGND VGND VPWR VPWR sky130_fd_sc_hd__decap_8
XFILLER_0_49_21 VPWR VGND VPWR VGND sky130_ef_sc_hd__decap_12
X_2562_ _1419_ VGND VGND VPWR VPWR _1671_ sky130_fd_sc_hd__clkbuf_4
X_2631_ VGND VGND VPWR VPWR _1739_ _1737_ _1738_ _1716_ Mux
X_2700_ VGND VGND VPWR VPWR _1776_ _1808_ _1807_ Nand_gate
X_3680_ VGND VGND VPWR VPWR _0660_ _0306_ inverter
X_4163_ VPWR VGND VGND VPWR net18 _1181_ _1030_ Xnor
X_4232_ VGND VGND VPWR VPWR _1565_ _1209_ _1256_ Nor_gate
X_4301_ VGND VGND VPWR VPWR net24 _1330_ _1287_ Nand_gate
X_2493_ VGND VGND VPWR VPWR _1598_ _1602_ _1601_ Nand_gate
X_3114_ VGND VGND VPWR VPWR _0047_ net31 _1316_ _1607_ Mux
X_4094_ VGND VGND VPWR VPWR _1107_ net19 net18 _1676_ Mux
X_3045_ net25 VGND VGND VPWR VPWR _2147_ sky130_fd_sc_hd__clkbuf_4
XFILLER_0_45_143 VGND VGND VPWR VPWR sky130_fd_sc_hd__decap_4
XFILLER_0_45_110 VGND VGND VPWR VPWR sky130_fd_sc_hd__fill_2
X_3947_ VGND VGND VPWR VPWR _0937_ _0947_ _0948_ Nor_gate
XFILLER_0_33_305 VGND VGND VPWR VPWR sky130_fd_sc_hd__decap_6
X_3878_ VGND VGND VPWR VPWR _0658_ _0874_ _0772_ Nand_gate
X_2829_ VGND VGND VPWR VPWR _1918_ _1934_ _1935_ Nor_gate
XFILLER_0_5_273 VGND VGND VPWR VPWR sky130_fd_sc_hd__decap_6
XTAP_290 VGND VPWR sky130_fd_sc_hd__tapvpwrvgnd_1
XFILLER_0_51_146 VPWR VGND VPWR VGND sky130_ef_sc_hd__decap_12
XFILLER_0_51_113 VPWR VGND VPWR VGND sky130_ef_sc_hd__decap_12
XFILLER_0_36_176 VGND VGND VPWR VPWR sky130_fd_sc_hd__fill_1
XFILLER_0_10_15 VPWR VGND VPWR VGND sky130_ef_sc_hd__decap_12
XFILLER_0_10_59 VGND VGND VPWR VPWR sky130_fd_sc_hd__fill_1
XFILLER_0_35_45 VGND VGND VPWR VPWR sky130_fd_sc_hd__decap_8
XFILLER_0_51_55 VGND VGND VPWR VPWR sky130_fd_sc_hd__fill_1
X_3732_ VPWR VGND VGND VPWR net47 _0716_ _0715_ Xnor
X_3801_ VGND VGND VPWR VPWR _0452_ _0727_ _0791_ Nor_gate
X_2614_ VGND VGND VPWR VPWR _1722_ _1721_ inverter
X_2545_ VGND VGND VPWR VPWR _1654_ _1652_ _1653_ _1589_ Mux
X_3663_ VGND VGND VPWR VPWR _1766_ _0642_ _0519_ Nand_gate
XFILLER_0_2_221 VPWR VGND VPWR VGND sky130_ef_sc_hd__decap_12
X_3594_ VGND VGND VPWR VPWR _0543_ _0439_ _0567_ Nor_gate
X_2476_ VGND VGND VPWR VPWR _1585_ net37 inverter
X_4146_ VGND VGND VPWR VPWR _0247_ _1117_ _1163_ Nor_gate
X_4215_ VGND VGND VPWR VPWR _1212_ _1237_ _1238_ Nor_gate
X_3028_ VGND VGND VPWR VPWR _2120_ _2131_ _2130_ Nand_gate
X_4077_ VGND VGND VPWR VPWR _0782_ _1088_ _1087_ Nand_gate
XFILLER_0_33_146 VGND VGND VPWR VPWR sky130_fd_sc_hd__decap_8
XFILLER_0_18_165 VPWR VGND VPWR VGND sky130_ef_sc_hd__decap_12
X_4000_ VGND VGND VPWR VPWR _0108_ _1005_ _1006_ Nor_gate
XFILLER_0_46_66 VPWR VGND VPWR VGND sky130_ef_sc_hd__decap_12
X_2192_ VGND VGND VPWR VPWR _0246_ _0268_ _0257_ Nand_gate
X_2330_ VPWR VGND VGND VPWR _1438_ _1439_ _1428_ Xnor
X_2261_ net7 VGND VGND VPWR VPWR _1014_ sky130_fd_sc_hd__clkbuf_4
XFILLER_0_47_205 VGND VGND VPWR VPWR sky130_fd_sc_hd__decap_8
XFILLER_0_1_13 VPWR VGND VPWR VGND sky130_ef_sc_hd__decap_12
XFILLER_0_1_57 VPWR VGND VPWR VGND sky130_ef_sc_hd__decap_12
X_3715_ VGND VGND VPWR VPWR _0698_ _0695_ _0697_ _1870_ Mux
XFILLER_0_55_271 VGND VGND VPWR VPWR sky130_fd_sc_hd__decap_8
XFILLER_0_47_249 VPWR VGND VPWR VGND sky130_ef_sc_hd__decap_12
XFILLER_0_7_313 VGND VGND VPWR VPWR sky130_fd_sc_hd__decap_8
XFILLER_0_15_124 VGND VGND VPWR VPWR sky130_fd_sc_hd__fill_2
X_2528_ VGND VGND VPWR VPWR _1427_ _1637_ _1424_ Nand_gate
X_3646_ VGND VGND VPWR VPWR _1766_ _0623_ _1773_ Nand_gate
X_3577_ VGND VGND VPWR VPWR _0544_ _0548_ _0547_ Nand_gate
X_4129_ VGND VGND VPWR VPWR _1141_ _1144_ _1145_ Nor_gate
X_2459_ VGND VGND VPWR VPWR _1565_ net58 _1568_ Nor_gate
XFILLER_0_46_271 VGND VGND VPWR VPWR sky130_fd_sc_hd__decap_3
XFILLER_0_14_190 VGND VGND VPWR VPWR sky130_fd_sc_hd__decap_6
XFILLER_0_37_293 VPWR VGND VPWR VGND sky130_ef_sc_hd__decap_12
XFILLER_0_32_57 VPWR VGND VPWR VGND sky130_ef_sc_hd__decap_12
XFILLER_0_32_35 VGND VGND VPWR VPWR sky130_fd_sc_hd__decap_8
X_3500_ VGND VGND VPWR VPWR _0345_ _0465_ _0466_ Nor_gate
X_3362_ VGND VGND VPWR VPWR _1624_ _2008_ _0316_ Nor_gate
X_2313_ VGND VGND VPWR VPWR _1419_ _1422_ _1421_ Nand_gate
X_3431_ VGND VGND VPWR VPWR _0388_ _0391_ _0390_ Nand_gate
XFILLER_0_12_138 VGND VGND VPWR VPWR sky130_fd_sc_hd__fill_2
XFILLER_0_32_7 VGND VGND VPWR VPWR sky130_fd_sc_hd__decap_4
X_3293_ VGND VGND VPWR VPWR _1766_ _0241_ _0240_ Nand_gate
X_2175_ VGND VGND VPWR VPWR net33 _0073_ _0084_ Nor_gate
X_2244_ VGND VGND VPWR VPWR _0571_ _0830_ _0819_ Nand_gate
XFILLER_0_7_121 VGND VGND VPWR VPWR sky130_fd_sc_hd__fill_2
X_3629_ VGND VGND VPWR VPWR _0355_ _0604_ _0605_ Nor_gate
XFILLER_0_11_193 VGND VGND VPWR VPWR sky130_fd_sc_hd__fill_2
XPHY_100 VGND VGND VPWR VPWR sky130_fd_sc_hd__decap_3
XPHY_111 VGND VGND VPWR VPWR sky130_fd_sc_hd__decap_3
XFILLER_0_34_274 VGND VGND VPWR VPWR sky130_fd_sc_hd__decap_3
XFILLER_0_1_308 VPWR VGND VPWR VGND sky130_ef_sc_hd__decap_12
XTAP_119 VGND VPWR sky130_fd_sc_hd__tapvpwrvgnd_1
XFILLER_0_27_57 VGND VGND VPWR VPWR sky130_fd_sc_hd__fill_1
X_2931_ VGND VGND VPWR VPWR _2033_ _2034_ _2035_ Nor_gate
X_3980_ VGND VGND VPWR VPWR _0975_ _0984_ _0983_ Nand_gate
XPHY_2 VGND VGND VPWR VPWR sky130_fd_sc_hd__decap_3
XFILLER_0_40_233 VPWR VGND VPWR VGND sky130_ef_sc_hd__decap_12
XFILLER_0_40_200 VGND VGND VPWR VPWR sky130_fd_sc_hd__decap_6
X_2793_ VGND VGND VPWR VPWR _1893_ _1896_ _1899_ Nor_gate
X_2862_ VGND VGND VPWR VPWR _1966_ _1777_ _1967_ Nor_gate
X_3345_ VGND VGND VPWR VPWR _0036_ _0297_ _0296_ Nand_gate
X_3276_ VGND VGND VPWR VPWR _0219_ _0221_ _0222_ Nor_gate
X_3414_ VGND VGND VPWR VPWR _0370_ _0371_ _0372_ Nor_gate
XFILLER_0_23_3 VGND VGND VPWR VPWR sky130_fd_sc_hd__decap_4
X_2227_ VGND VGND VPWR VPWR _0647_ net10 inverter
XFILLER_0_48_333 VPWR VGND VPWR VGND sky130_ef_sc_hd__decap_12
XFILLER_0_16_241 VGND VGND VPWR VPWR sky130_fd_sc_hd__decap_4
XFILLER_0_13_15 VPWR VGND VPWR VGND sky130_ef_sc_hd__decap_12
XFILLER_0_1_105 VGND VGND VPWR VPWR sky130_fd_sc_hd__decap_6
XFILLER_0_38_45 VGND VGND VPWR VPWR sky130_fd_sc_hd__fill_1
XFILLER_0_38_23 VGND VGND VPWR VPWR sky130_fd_sc_hd__decap_4
X_3130_ VGND VGND VPWR VPWR _0063_ _0064_ _0065_ Nor_gate
XFILLER_0_1_149 VPWR VGND VPWR VGND sky130_ef_sc_hd__decap_12
XFILLER_0_54_66 VGND VGND VPWR VPWR sky130_fd_sc_hd__fill_1
X_3061_ VGND VGND VPWR VPWR _1982_ _2162_ _2163_ Nor_gate
X_2914_ VGND VGND VPWR VPWR _2010_ _2019_ _2018_ Nand_gate
X_2845_ VGND VGND VPWR VPWR _1946_ _1951_ _1950_ Nand_gate
X_3963_ VGND VGND VPWR VPWR _0781_ _0962_ _0965_ Nor_gate
XFILLER_0_9_216 VGND VGND VPWR VPWR sky130_fd_sc_hd__fill_1
XFILLER_0_9_238 VGND VGND VPWR VPWR sky130_fd_sc_hd__decap_8
X_3894_ VGND VGND VPWR VPWR _0890_ _0835_ _0891_ Nor_gate
X_2776_ VGND VGND VPWR VPWR _1877_ _1883_ _1882_ Nand_gate
XFILLER_0_13_288 VGND VGND VPWR VPWR sky130_fd_sc_hd__fill_1
XTAP_483 VGND VPWR sky130_fd_sc_hd__tapvpwrvgnd_1
XTAP_472 VGND VPWR sky130_fd_sc_hd__tapvpwrvgnd_1
XTAP_461 VGND VPWR sky130_fd_sc_hd__tapvpwrvgnd_1
XTAP_450 VGND VPWR sky130_fd_sc_hd__tapvpwrvgnd_1
X_3259_ VGND VGND VPWR VPWR _0205_ _1800_ _1693_ _1197_ Mux
X_3328_ VGND VGND VPWR VPWR net39 net38 _0279_ Nor_gate
XFILLER_0_48_141 VGND VGND VPWR VPWR sky130_fd_sc_hd__decap_6
XFILLER_0_48_130 VGND VGND VPWR VPWR sky130_fd_sc_hd__decap_8
XFILLER_0_48_185 VGND VGND VPWR VPWR sky130_fd_sc_hd__fill_1
XFILLER_0_54_133 VGND VGND VPWR VPWR sky130_fd_sc_hd__decap_6
XFILLER_0_39_196 VGND VGND VPWR VPWR sky130_fd_sc_hd__decap_4
XFILLER_0_39_152 VGND VGND VPWR VPWR sky130_fd_sc_hd__decap_6
XFILLER_0_27_325 VGND VGND VPWR VPWR sky130_fd_sc_hd__decap_4
XFILLER_0_24_25 VGND VGND VPWR VPWR sky130_fd_sc_hd__decap_3
XFILLER_0_6_208 VGND VGND VPWR VPWR sky130_fd_sc_hd__decap_3
XFILLER_0_6_219 VPWR VGND VPWR VGND sky130_ef_sc_hd__decap_12
XFILLER_0_49_33 VPWR VGND VPWR VGND sky130_ef_sc_hd__decap_12
XFILLER_0_42_339 VGND VGND VPWR VPWR sky130_fd_sc_hd__fill_2
X_2630_ VGND VGND VPWR VPWR _1738_ net11 net13 net37 Mux
X_2561_ VGND VGND VPWR VPWR _1670_ _1665_ _1669_ _1633_ Mux
X_4300_ _1329_ VGND VGND VPWR VPWR net92 sky130_fd_sc_hd__buf_1
X_2492_ VGND VGND VPWR VPWR net34 _1600_ _1601_ Nor_gate
X_3113_ VGND VGND VPWR VPWR _0046_ _2092_ inverter
XFILLER_0_49_66 VGND VGND VPWR VPWR sky130_fd_sc_hd__decap_8
X_4093_ VGND VGND VPWR VPWR _1103_ _1106_ _1105_ Nand_gate
X_4162_ VGND VGND VPWR VPWR _1180_ _0983_ inverter
X_4231_ VGND VGND VPWR VPWR _1565_ _1255_ _1209_ Nand_gate
X_3044_ VGND VGND VPWR VPWR _1625_ _2145_ _2146_ Nor_gate
XFILLER_0_45_199 VGND VGND VPWR VPWR sky130_fd_sc_hd__fill_2
XFILLER_0_45_166 VGND VGND VPWR VPWR sky130_fd_sc_hd__fill_2
XFILLER_0_45_133 VGND VGND VPWR VPWR sky130_fd_sc_hd__fill_1
X_2828_ VGND VGND VPWR VPWR _1934_ _1933_ inverter
X_3946_ VGND VGND VPWR VPWR _2152_ _0946_ _0947_ Nor_gate
XFILLER_0_18_336 VGND VGND VPWR VPWR sky130_fd_sc_hd__decap_8
XFILLER_0_5_263 VGND VGND VPWR VPWR sky130_fd_sc_hd__decap_6
X_3877_ VGND VGND VPWR VPWR _0824_ _0871_ _0872_ Nor_gate
X_2759_ VGND VGND VPWR VPWR _1436_ _1865_ _1866_ Nor_gate
XTAP_291 VGND VPWR sky130_fd_sc_hd__tapvpwrvgnd_1
XTAP_280 VGND VPWR sky130_fd_sc_hd__tapvpwrvgnd_1
XFILLER_0_36_144 VGND VGND VPWR VPWR sky130_fd_sc_hd__fill_1
XFILLER_0_51_169 VGND VGND VPWR VPWR sky130_fd_sc_hd__decap_8
XFILLER_0_51_158 VGND VGND VPWR VPWR sky130_fd_sc_hd__decap_8
XFILLER_0_51_125 VGND VGND VPWR VPWR sky130_fd_sc_hd__decap_3
XFILLER_0_10_27 VGND VGND VPWR VPWR sky130_fd_sc_hd__fill_1
XFILLER_0_42_136 VGND VGND VPWR VPWR sky130_fd_sc_hd__decap_4
XFILLER_0_27_177 VGND VGND VPWR VPWR sky130_fd_sc_hd__fill_2
XFILLER_0_27_166 VGND VGND VPWR VPWR sky130_fd_sc_hd__fill_2
X_3731_ VGND VGND VPWR VPWR _0653_ _0715_ _0714_ Nand_gate
X_3800_ VGND VGND VPWR VPWR _0452_ _0790_ _0727_ Nand_gate
X_3662_ VGND VGND VPWR VPWR net45 _0641_ _2002_ Nand_gate
X_2613_ VGND VGND VPWR VPWR _1721_ _1719_ _1720_ _1589_ Mux
X_2475_ VGND VGND VPWR VPWR _1426_ _1584_ _1439_ Nand_gate
XFILLER_0_2_233 VPWR VGND VPWR VGND sky130_ef_sc_hd__decap_12
X_3593_ VGND VGND VPWR VPWR _0563_ _0566_ _0565_ Nand_gate
X_2544_ VGND VGND VPWR VPWR _1653_ _0647_ _0603_ _1615_ Mux
X_4145_ VGND VGND VPWR VPWR _1766_ _1162_ _1161_ Nand_gate
X_4214_ VGND VGND VPWR VPWR _1221_ _1237_ _1236_ Nand_gate
X_4076_ VGND VGND VPWR VPWR _0881_ _1086_ _1087_ Nor_gate
X_3027_ VGND VGND VPWR VPWR _2123_ _2129_ _2130_ Nor_gate
XFILLER_0_33_169 VGND VGND VPWR VPWR sky130_fd_sc_hd__decap_8
XFILLER_0_33_158 VGND VGND VPWR VPWR sky130_fd_sc_hd__decap_3
XFILLER_0_33_125 VGND VGND VPWR VPWR sky130_fd_sc_hd__decap_4
XFILLER_0_18_177 VGND VGND VPWR VPWR sky130_fd_sc_hd__fill_1
X_3929_ VGND VGND VPWR VPWR _0923_ _0929_ _0926_ Nand_gate
XFILLER_0_41_191 VGND VGND VPWR VPWR sky130_fd_sc_hd__fill_2
XFILLER_0_41_180 VGND VGND VPWR VPWR sky130_fd_sc_hd__fill_1
XFILLER_0_21_15 VGND VGND VPWR VPWR sky130_fd_sc_hd__fill_2
XFILLER_0_12_309 VGND VGND VPWR VPWR sky130_fd_sc_hd__decap_6
XFILLER_0_46_78 VGND VGND VPWR VPWR sky130_fd_sc_hd__decap_6
XFILLER_0_46_56 VGND VGND VPWR VPWR sky130_fd_sc_hd__fill_1
X_2191_ VPWR VGND VGND VPWR net17 _0257_ net53 Xnor
X_2260_ VGND VGND VPWR VPWR _0970_ _0992_ _1003_ Nor_gate
XFILLER_0_1_25 VPWR VGND VPWR VGND sky130_ef_sc_hd__decap_12
XFILLER_0_1_69 VPWR VGND VPWR VGND sky130_ef_sc_hd__decap_12
XFILLER_0_7_303 VGND VGND VPWR VPWR sky130_fd_sc_hd__decap_6
X_3714_ VGND VGND VPWR VPWR _0697_ _0574_ _0696_ _2155_ Mux
X_3645_ VGND VGND VPWR VPWR _1922_ _0622_ _1759_ Nand_gate
XFILLER_0_15_103 VGND VGND VPWR VPWR sky130_fd_sc_hd__fill_1
XFILLER_0_15_169 VPWR VGND VPWR VGND sky130_ef_sc_hd__decap_12
XFILLER_0_53_3 VPWR VGND VPWR VGND sky130_ef_sc_hd__decap_12
X_2527_ net63 VGND VGND VPWR VPWR _1636_ sky130_fd_sc_hd__buf_2
XFILLER_0_23_191 VPWR VGND VPWR VGND sky130_ef_sc_hd__decap_12
X_2458_ VGND VGND VPWR VPWR _1567_ _0159_ inverter
X_3576_ VGND VGND VPWR VPWR _0482_ _0547_ _0546_ Nand_gate
X_4128_ VGND VGND VPWR VPWR _0676_ _1144_ _1142_ Nand_gate
X_4059_ VGND VGND VPWR VPWR _1065_ _1069_ _1070_ Nor_gate
X_2389_ VGND VGND VPWR VPWR _0895_ _1497_ _1498_ Nor_gate
XFILLER_0_46_283 VPWR VGND VPWR VGND sky130_ef_sc_hd__decap_12
XFILLER_0_32_47 VGND VGND VPWR VPWR sky130_fd_sc_hd__decap_6
XFILLER_0_52_220 VGND VGND VPWR VPWR sky130_fd_sc_hd__fill_1
XFILLER_0_32_69 VGND VGND VPWR VPWR sky130_fd_sc_hd__decap_6
X_3361_ VGND VGND VPWR VPWR _1671_ _0315_ _1991_ Nand_gate
X_2312_ VGND VGND VPWR VPWR _1421_ _1420_ inverter
X_3292_ VGND VGND VPWR VPWR _0232_ _0240_ _0239_ Nand_gate
X_3430_ VGND VGND VPWR VPWR _0108_ _0390_ _0389_ Nand_gate
X_2174_ VGND VGND VPWR VPWR _0029_ _0073_ _0062_ Nand_gate
X_2243_ VGND VGND VPWR VPWR _0712_ _0809_ _0819_ Nor_gate
XFILLER_0_22_91 VGND VGND VPWR VPWR sky130_fd_sc_hd__fill_1
X_3628_ VGND VGND VPWR VPWR net44 _0556_ _0604_ Nor_gate
X_3559_ VGND VGND VPWR VPWR _0529_ _0166_ inverter
XFILLER_0_9_9 VPWR VGND VPWR VGND sky130_ef_sc_hd__decap_12
XPHY_112 VGND VGND VPWR VPWR sky130_fd_sc_hd__decap_3
XPHY_101 VGND VGND VPWR VPWR sky130_fd_sc_hd__decap_3
XFILLER_0_26_209 VGND VGND VPWR VPWR sky130_fd_sc_hd__fill_1
XFILLER_0_57_334 VGND VGND VPWR VPWR sky130_fd_sc_hd__fill_2
X_2930_ VGND VGND VPWR VPWR _1755_ _1993_ _2034_ Nor_gate
X_2861_ VGND VGND VPWR VPWR _1889_ _1637_ _1966_ Nor_gate
XPHY_3 VGND VGND VPWR VPWR sky130_fd_sc_hd__decap_3
XFILLER_0_40_245 VGND VGND VPWR VPWR sky130_fd_sc_hd__decap_4
X_2792_ VGND VGND VPWR VPWR net34 _1898_ _1683_ Nand_gate
XFILLER_0_4_147 VGND VGND VPWR VPWR sky130_fd_sc_hd__decap_4
XFILLER_0_7_57 VGND VGND VPWR VPWR sky130_fd_sc_hd__decap_6
X_3413_ VGND VGND VPWR VPWR _1491_ _0368_ _0371_ Nor_gate
XFILLER_0_40_289 VPWR VGND VPWR VGND sky130_ef_sc_hd__decap_12
X_3344_ VGND VGND VPWR VPWR _1475_ _0296_ _0091_ Nand_gate
X_3275_ VGND VGND VPWR VPWR _0220_ _0171_ _0221_ Nor_gate
X_2226_ VGND VGND VPWR VPWR _0593_ _0636_ _0625_ Nand_gate
XFILLER_0_48_345 VGND VGND VPWR VPWR sky130_fd_sc_hd__fill_2
XFILLER_0_16_3 VGND VGND VPWR VPWR sky130_fd_sc_hd__decap_3
XFILLER_0_31_212 VPWR VGND VPWR VGND sky130_ef_sc_hd__decap_12
XFILLER_0_39_345 VGND VGND VPWR VPWR sky130_fd_sc_hd__fill_2
XFILLER_0_39_312 VGND VGND VPWR VPWR sky130_fd_sc_hd__fill_1
XFILLER_0_13_27 VGND VGND VPWR VPWR sky130_fd_sc_hd__decap_8
XFILLER_0_13_38 VGND VGND VPWR VPWR sky130_fd_sc_hd__decap_6
X_3060_ VGND VGND VPWR VPWR _2162_ _2160_ _2161_ _1625_ Mux
XFILLER_0_45_337 VGND VGND VPWR VPWR sky130_fd_sc_hd__decap_8
X_2913_ VGND VGND VPWR VPWR _1982_ _2017_ _2018_ Nor_gate
X_2844_ VGND VGND VPWR VPWR _1948_ _1949_ _1950_ Nor_gate
X_3962_ VGND VGND VPWR VPWR _0552_ _0964_ _0963_ Nand_gate
X_3893_ VGND VGND VPWR VPWR _0681_ _0890_ _0889_ Nand_gate
X_2775_ VGND VGND VPWR VPWR _1878_ _1881_ _1882_ Nor_gate
XFILLER_0_0_161 VGND VGND VPWR VPWR sky130_fd_sc_hd__fill_1
XTAP_473 VGND VPWR sky130_fd_sc_hd__tapvpwrvgnd_1
X_3327_ VGND VGND VPWR VPWR net71 _0277_ inverter
XTAP_462 VGND VPWR sky130_fd_sc_hd__tapvpwrvgnd_1
XTAP_451 VGND VPWR sky130_fd_sc_hd__tapvpwrvgnd_1
XTAP_440 VGND VPWR sky130_fd_sc_hd__tapvpwrvgnd_1
X_2209_ net13 VGND VGND VPWR VPWR _0452_ sky130_fd_sc_hd__clkbuf_4
X_3258_ VGND VGND VPWR VPWR _1473_ _1677_ _0204_ Nor_gate
X_3189_ VGND VGND VPWR VPWR _1880_ _0129_ _0128_ Nand_gate
XFILLER_0_36_315 VPWR VGND VPWR VGND sky130_ef_sc_hd__decap_12
XFILLER_0_36_304 VGND VGND VPWR VPWR sky130_fd_sc_hd__fill_1
XFILLER_0_48_197 VPWR VGND VPWR VGND sky130_ef_sc_hd__decap_12
XFILLER_0_5_3 VPWR VGND VPWR VGND sky130_ef_sc_hd__decap_12
XFILLER_0_27_337 VGND VGND VPWR VPWR sky130_fd_sc_hd__fill_2
XFILLER_0_27_315 VGND VGND VPWR VPWR sky130_fd_sc_hd__decap_6
XFILLER_0_27_304 VGND VGND VPWR VPWR sky130_fd_sc_hd__fill_2
XFILLER_0_49_45 VGND VGND VPWR VPWR sky130_fd_sc_hd__fill_2
X_2560_ VGND VGND VPWR VPWR _1669_ _1666_ _1668_ _1589_ Mux
X_4230_ VGND VGND VPWR VPWR _1250_ _1253_ _1254_ Nor_gate
X_2491_ VGND VGND VPWR VPWR net35 _1600_ _1599_ Nand_gate
X_3043_ VGND VGND VPWR VPWR _2145_ _1902_ _1907_ _1606_ Mux
X_4161_ VGND VGND VPWR VPWR net88 _1179_ inverter
X_4092_ VGND VGND VPWR VPWR _0370_ _1104_ _1105_ Nor_gate
X_3112_ VGND VGND VPWR VPWR _0041_ _0045_ _0044_ Nand_gate
X_3945_ VGND VGND VPWR VPWR _0738_ _0946_ _0945_ Nand_gate
XFILLER_0_18_326 VGND VGND VPWR VPWR sky130_fd_sc_hd__decap_6
XFILLER_0_18_304 VGND VGND VPWR VPWR sky130_fd_sc_hd__fill_1
X_2758_ VGND VGND VPWR VPWR _1628_ _1864_ _1865_ Nor_gate
X_2827_ VGND VGND VPWR VPWR _1924_ _1932_ _1933_ Nor_gate
XFILLER_0_30_91 VGND VGND VPWR VPWR sky130_fd_sc_hd__decap_4
XFILLER_0_5_220 VGND VGND VPWR VPWR sky130_fd_sc_hd__decap_4
X_3876_ VGND VGND VPWR VPWR _0763_ _0823_ _0871_ Nor_gate
X_2689_ VGND VGND VPWR VPWR _1589_ _1796_ _1797_ Nor_gate
X_4359_ VGND VGND VPWR VPWR net75 _1392_ _1393_ Nor_gate
XTAP_292 VGND VPWR sky130_fd_sc_hd__tapvpwrvgnd_1
XTAP_281 VGND VPWR sky130_fd_sc_hd__tapvpwrvgnd_1
XTAP_270 VGND VPWR sky130_fd_sc_hd__tapvpwrvgnd_1
X_2612_ VGND VGND VPWR VPWR _1720_ _1420_ net27 _1433_ Mux
XFILLER_0_42_126 VGND VGND VPWR VPWR sky130_fd_sc_hd__decap_6
XFILLER_0_42_115 VGND VGND VPWR VPWR sky130_fd_sc_hd__decap_4
X_3661_ VGND VGND VPWR VPWR _1798_ _0639_ _0640_ Nor_gate
XFILLER_0_27_134 VGND VGND VPWR VPWR sky130_fd_sc_hd__decap_6
X_3592_ VGND VGND VPWR VPWR _0042_ _0564_ _0565_ Nor_gate
X_3730_ VGND VGND VPWR VPWR net46 _0714_ _0215_ Nand_gate
X_2543_ VGND VGND VPWR VPWR _1652_ _1651_ inverter
X_4213_ VGND VGND VPWR VPWR _1224_ _1235_ _1236_ Nor_gate
X_2474_ VGND VGND VPWR VPWR _1583_ _1305_ inverter
XFILLER_0_2_245 VGND VGND VPWR VPWR sky130_fd_sc_hd__decap_6
X_4144_ VGND VGND VPWR VPWR _1161_ _2147_ _0238_ _0738_ Mux
X_3026_ VGND VGND VPWR VPWR _2127_ _2129_ _2128_ Nand_gate
X_4075_ VGND VGND VPWR VPWR _1086_ _0961_ inverter
XFILLER_0_58_281 VGND VGND VPWR VPWR sky130_fd_sc_hd__fill_2
XFILLER_0_18_101 VPWR VGND VPWR VGND sky130_ef_sc_hd__decap_12
X_3928_ VGND VGND VPWR VPWR _0923_ _0926_ _0928_ Nor_gate
X_3859_ VGND VGND VPWR VPWR _0843_ _0854_ _0853_ Nand_gate
XFILLER_0_14_340 VGND VGND VPWR VPWR sky130_fd_sc_hd__decap_3
XFILLER_0_24_159 VGND VGND VPWR VPWR sky130_fd_sc_hd__fill_1
XFILLER_0_24_115 VGND VGND VPWR VPWR sky130_fd_sc_hd__decap_3
XFILLER_0_32_181 VPWR VGND VPWR VGND sky130_ef_sc_hd__decap_12
X_2190_ VPWR VGND VGND VPWR net18 _0246_ net54 Xnor
XFILLER_0_1_37 VGND VGND VPWR VPWR sky130_fd_sc_hd__decap_4
XFILLER_0_7_337 VGND VGND VPWR VPWR sky130_fd_sc_hd__decap_8
X_3713_ VGND VGND VPWR VPWR _0696_ _0679_ _0733_ _1608_ Mux
XFILLER_0_30_129 VGND VGND VPWR VPWR sky130_fd_sc_hd__decap_8
X_3575_ VGND VGND VPWR VPWR _1014_ _0546_ _0545_ Nand_gate
XFILLER_0_11_60 VGND VGND VPWR VPWR sky130_fd_sc_hd__decap_4
X_3644_ VGND VGND VPWR VPWR _0618_ _0620_ _0621_ Nor_gate
X_2526_ VGND VGND VPWR VPWR _1625_ _1635_ _1634_ Nand_gate
X_2457_ VGND VGND VPWR VPWR _1565_ _0181_ _1566_ Nor_gate
X_2388_ VGND VGND VPWR VPWR _1493_ _1496_ _1497_ Nor_gate
X_3009_ VGND VGND VPWR VPWR _2112_ _1844_ inverter
XFILLER_0_38_207 VGND VGND VPWR VPWR sky130_fd_sc_hd__decap_3
X_4127_ VGND VGND VPWR VPWR _1138_ _1142_ _1140_ Nand_gate
X_4058_ VGND VGND VPWR VPWR _0511_ _1067_ _1069_ Nor_gate
XFILLER_0_46_295 VPWR VGND VPWR VGND sky130_ef_sc_hd__decap_12
XFILLER_0_46_251 VGND VGND VPWR VPWR sky130_fd_sc_hd__fill_1
XFILLER_0_21_118 VPWR VGND VPWR VGND sky130_ef_sc_hd__decap_12
XFILLER_0_16_49 VGND VGND VPWR VPWR sky130_fd_sc_hd__fill_2
XFILLER_0_29_207 VGND VGND VPWR VPWR sky130_fd_sc_hd__decap_8
XFILLER_0_4_307 VGND VGND VPWR VPWR sky130_fd_sc_hd__fill_1
XFILLER_0_12_118 VPWR VGND VPWR VGND sky130_ef_sc_hd__decap_12
X_2311_ net26 VGND VGND VPWR VPWR _1420_ sky130_fd_sc_hd__clkbuf_4
X_3291_ VGND VGND VPWR VPWR _0228_ _0239_ _0238_ Nand_gate
X_3360_ VGND VGND VPWR VPWR _1636_ _0314_ _0313_ Nand_gate
XFILLER_0_20_184 VGND VGND VPWR VPWR sky130_fd_sc_hd__decap_6
XFILLER_0_20_173 VGND VGND VPWR VPWR sky130_fd_sc_hd__decap_4
X_2242_ VGND VGND VPWR VPWR _0776_ _0809_ _0798_ Nand_gate
X_2173_ VGND VGND VPWR VPWR _0040_ _0062_ _0051_ Nand_gate
XFILLER_0_18_7 VGND VGND VPWR VPWR sky130_fd_sc_hd__fill_1
XFILLER_0_28_295 VGND VGND VPWR VPWR sky130_fd_sc_hd__decap_4
XFILLER_0_28_251 VGND VGND VPWR VPWR sky130_fd_sc_hd__fill_1
XFILLER_0_7_167 VGND VGND VPWR VPWR sky130_fd_sc_hd__fill_1
X_2509_ VGND VGND VPWR VPWR _1589_ _1618_ _1617_ Nand_gate
X_3558_ _0527_ VGND VGND VPWR VPWR net75 sky130_fd_sc_hd__buf_1
X_3627_ _0602_ VGND VGND VPWR VPWR net76 sky130_fd_sc_hd__buf_1
X_3489_ VGND VGND VPWR VPWR _0454_ _2095_ _0453_ _1614_ Mux
XPHY_113 VGND VGND VPWR VPWR sky130_fd_sc_hd__decap_3
XPHY_102 VGND VGND VPWR VPWR sky130_fd_sc_hd__decap_3
XFILLER_0_34_232 VGND VGND VPWR VPWR sky130_fd_sc_hd__decap_8
XFILLER_0_57_302 VPWR VGND VPWR VGND sky130_ef_sc_hd__decap_12
X_2860_ VGND VGND VPWR VPWR _1958_ _1965_ _1964_ Nand_gate
X_2791_ VGND VGND VPWR VPWR _1893_ _1897_ _1896_ Nand_gate
XPHY_4 VGND VGND VPWR VPWR sky130_fd_sc_hd__decap_3
XFILLER_0_40_279 VGND VGND VPWR VPWR sky130_fd_sc_hd__fill_1
XFILLER_0_25_298 VPWR VGND VPWR VGND sky130_ef_sc_hd__decap_12
XFILLER_0_25_287 VGND VGND VPWR VPWR sky130_fd_sc_hd__decap_8
XFILLER_0_0_321 VGND VGND VPWR VPWR sky130_fd_sc_hd__decap_8
X_3412_ _1791_ VGND VGND VPWR VPWR _0370_ sky130_fd_sc_hd__clkbuf_4
X_3343_ VGND VGND VPWR VPWR _0295_ _0095_ inverter
X_3274_ VGND VGND VPWR VPWR _0150_ _0155_ _0220_ Nor_gate
X_2225_ VGND VGND VPWR VPWR _0603_ _0625_ _0614_ Nand_gate
X_2989_ VGND VGND VPWR VPWR _2092_ net29 _1410_ _1607_ Mux
XFILLER_0_16_210 VGND VGND VPWR VPWR sky130_fd_sc_hd__fill_1
XFILLER_0_31_279 VGND VGND VPWR VPWR sky130_fd_sc_hd__fill_1
XFILLER_0_54_305 VGND VGND VPWR VPWR sky130_fd_sc_hd__decap_3
XFILLER_0_39_324 VPWR VGND VPWR VGND sky130_ef_sc_hd__decap_12
XFILLER_0_22_279 VGND VGND VPWR VPWR sky130_fd_sc_hd__decap_4
XFILLER_0_57_110 VGND VGND VPWR VPWR sky130_fd_sc_hd__fill_2
XFILLER_0_54_79 VGND VGND VPWR VPWR sky130_fd_sc_hd__fill_2
X_2912_ VGND VGND VPWR VPWR _2011_ _2016_ _2017_ Nor_gate
X_3961_ VGND VGND VPWR VPWR _0878_ _0962_ _0963_ Nor_gate
X_2774_ VGND VGND VPWR VPWR _1879_ _1880_ _1881_ Nor_gate
X_2843_ VGND VGND VPWR VPWR _1423_ _1684_ _1949_ Nor_gate
X_3892_ VGND VGND VPWR VPWR _0889_ _0726_ inverter
XTAP_441 VGND VPWR sky130_fd_sc_hd__tapvpwrvgnd_1
XTAP_430 VGND VPWR sky130_fd_sc_hd__tapvpwrvgnd_1
XFILLER_0_21_290 VGND VGND VPWR VPWR sky130_fd_sc_hd__fill_1
XFILLER_0_0_184 VGND VGND VPWR VPWR sky130_fd_sc_hd__decap_6
X_3326_ VGND VGND VPWR VPWR _0226_ _0276_ _0277_ Nor_gate
XTAP_474 VGND VPWR sky130_fd_sc_hd__tapvpwrvgnd_1
XTAP_463 VGND VPWR sky130_fd_sc_hd__tapvpwrvgnd_1
XTAP_452 VGND VPWR sky130_fd_sc_hd__tapvpwrvgnd_1
X_3257_ VGND VGND VPWR VPWR _1863_ _0202_ _0201_ Nand_gate
XFILLER_0_28_91 VGND VGND VPWR VPWR sky130_fd_sc_hd__fill_1
X_3188_ VGND VGND VPWR VPWR _1100_ _0128_ _1693_ Nand_gate
X_2208_ VGND VGND VPWR VPWR _0376_ _0430_ _0441_ Nor_gate
XFILLER_0_36_327 VGND VGND VPWR VPWR sky130_fd_sc_hd__decap_8
XFILLER_0_8_251 VGND VGND VPWR VPWR sky130_fd_sc_hd__fill_1
XFILLER_0_54_179 VPWR VGND VPWR VGND sky130_ef_sc_hd__decap_12
XFILLER_0_54_102 VGND VGND VPWR VPWR sky130_fd_sc_hd__decap_8
XFILLER_0_40_15 VPWR VGND VPWR VGND sky130_ef_sc_hd__decap_12
X_4160_ VGND VGND VPWR VPWR _1145_ _1178_ _1179_ Nor_gate
X_2490_ VGND VGND VPWR VPWR _1599_ net36 inverter
XFILLER_0_10_227 VPWR VGND VPWR VGND sky130_ef_sc_hd__decap_12
X_4091_ VGND VGND VPWR VPWR net19 _1043_ _1104_ Nor_gate
X_3111_ VGND VGND VPWR VPWR _0042_ _0043_ _0044_ Nor_gate
X_3042_ VGND VGND VPWR VPWR _2141_ _2143_ _2144_ Nor_gate
X_3944_ VGND VGND VPWR VPWR _0939_ _0945_ _0944_ Nand_gate
XFILLER_0_45_113 VGND VGND VPWR VPWR sky130_fd_sc_hd__decap_4
X_3875_ VPWR VGND VGND VPWR _0333_ _0870_ _0869_ Xnor
X_2688_ VGND VGND VPWR VPWR _1796_ _1795_ inverter
X_2757_ VGND VGND VPWR VPWR _1864_ _1428_ net12 _1615_ Mux
X_2826_ VGND VGND VPWR VPWR _1636_ _1931_ _1932_ Nor_gate
XFILLER_0_30_70 VGND VGND VPWR VPWR sky130_fd_sc_hd__fill_1
X_3309_ VGND VGND VPWR VPWR _0254_ _0259_ _0258_ Nand_gate
XTAP_293 VGND VPWR sky130_fd_sc_hd__tapvpwrvgnd_1
XTAP_282 VGND VPWR sky130_fd_sc_hd__tapvpwrvgnd_1
XTAP_271 VGND VPWR sky130_fd_sc_hd__tapvpwrvgnd_1
X_4289_ VGND VGND VPWR VPWR _1314_ _1317_ _1318_ Nor_gate
XTAP_260 VGND VPWR sky130_fd_sc_hd__tapvpwrvgnd_1
X_4358_ VGND VGND VPWR VPWR _1374_ _1392_ _1390_ Nand_gate
XFILLER_0_36_168 VGND VGND VPWR VPWR sky130_fd_sc_hd__decap_8
XFILLER_0_36_157 VGND VGND VPWR VPWR sky130_fd_sc_hd__decap_4
XFILLER_0_24_319 VGND VGND VPWR VPWR sky130_fd_sc_hd__fill_2
XFILLER_0_32_341 VGND VGND VPWR VPWR sky130_fd_sc_hd__fill_2
XFILLER_0_19_27 VGND VGND VPWR VPWR sky130_fd_sc_hd__fill_2
XFILLER_0_19_16 VGND VGND VPWR VPWR sky130_fd_sc_hd__fill_2
XFILLER_0_10_29 VPWR VGND VPWR VGND sky130_ef_sc_hd__decap_12
XFILLER_0_27_124 VGND VGND VPWR VPWR sky130_fd_sc_hd__decap_3
XFILLER_0_27_113 VGND VGND VPWR VPWR sky130_fd_sc_hd__fill_1
X_2611_ VGND VGND VPWR VPWR _1719_ net12 _1428_ _1667_ Mux
X_2542_ VGND VGND VPWR VPWR _1651_ net8 _0733_ _1610_ Mux
X_3660_ VGND VGND VPWR VPWR _1982_ _0639_ _0594_ Nand_gate
X_3591_ VGND VGND VPWR VPWR _0552_ _0562_ _0564_ Nor_gate
XFILLER_0_15_319 VGND VGND VPWR VPWR sky130_fd_sc_hd__fill_2
X_4143_ VGND VGND VPWR VPWR _1862_ _1159_ _1160_ Nor_gate
X_4212_ VGND VGND VPWR VPWR _1225_ _1235_ _1234_ Nand_gate
X_2473_ VGND VGND VPWR VPWR _0084_ _1580_ _1582_ Nor_gate
XFILLER_0_2_268 VPWR VGND VPWR VGND sky130_ef_sc_hd__decap_12
X_4074_ VGND VGND VPWR VPWR _1033_ _1084_ _1085_ Nor_gate
X_3025_ VGND VGND VPWR VPWR net65 _2128_ _2002_ Nand_gate
XFILLER_0_58_293 VGND VGND VPWR VPWR sky130_fd_sc_hd__decap_4
X_3858_ VGND VGND VPWR VPWR _2043_ _0853_ _0851_ Nand_gate
XFILLER_0_18_113 VGND VGND VPWR VPWR sky130_fd_sc_hd__decap_8
X_3927_ VGND VGND VPWR VPWR _0925_ _0885_ _0926_ Nor_gate
X_2809_ VGND VGND VPWR VPWR _1424_ _1914_ _1915_ Nor_gate
XFILLER_0_33_138 VGND VGND VPWR VPWR sky130_fd_sc_hd__fill_2
X_3789_ VGND VGND VPWR VPWR _0778_ _0777_ inverter
XFILLER_0_5_91 VGND VGND VPWR VPWR sky130_fd_sc_hd__fill_1
XFILLER_0_24_149 VGND VGND VPWR VPWR sky130_fd_sc_hd__fill_1
XFILLER_0_32_193 VGND VGND VPWR VPWR sky130_fd_sc_hd__decap_3
XFILLER_0_32_171 VGND VGND VPWR VPWR sky130_fd_sc_hd__decap_6
XFILLER_0_1_49 VGND VGND VPWR VPWR sky130_fd_sc_hd__fill_1
X_3712_ VGND VGND VPWR VPWR _0695_ _0694_ _0449_ _2155_ Mux
XFILLER_0_47_219 VGND VGND VPWR VPWR sky130_fd_sc_hd__decap_4
XFILLER_0_15_116 VGND VGND VPWR VPWR sky130_fd_sc_hd__decap_8
X_2525_ VGND VGND VPWR VPWR _1634_ _1629_ _1632_ _1633_ Mux
XFILLER_0_30_108 VGND VGND VPWR VPWR sky130_fd_sc_hd__fill_2
X_3574_ VGND VGND VPWR VPWR _0545_ _0480_ inverter
XFILLER_0_11_94 VGND VGND VPWR VPWR sky130_fd_sc_hd__decap_4
X_3643_ VGND VGND VPWR VPWR _0269_ _0620_ _0619_ Nand_gate
X_4126_ VGND VGND VPWR VPWR _1138_ _1140_ _1141_ Nor_gate
X_2456_ net22 VGND VGND VPWR VPWR _1565_ sky130_fd_sc_hd__buf_2
X_2387_ VGND VGND VPWR VPWR _0938_ _1495_ _1496_ Nor_gate
X_3008_ VGND VGND VPWR VPWR _2111_ _2110_ inverter
X_4057_ VGND VGND VPWR VPWR _1067_ _0513_ _0512_ _1066_ Mux
XFILLER_0_16_17 VGND VGND VPWR VPWR sky130_fd_sc_hd__fill_2
XFILLER_0_32_27 VGND VGND VPWR VPWR sky130_fd_sc_hd__fill_1
XFILLER_0_29_219 VGND VGND VPWR VPWR sky130_fd_sc_hd__decap_4
XFILLER_0_20_141 VGND VGND VPWR VPWR sky130_fd_sc_hd__fill_2
XFILLER_0_57_57 VPWR VGND VPWR VGND sky130_ef_sc_hd__decap_12
XFILLER_0_57_13 VPWR VGND VPWR VGND sky130_ef_sc_hd__decap_12
X_2310_ net62 VGND VGND VPWR VPWR _1419_ sky130_fd_sc_hd__clkbuf_4
X_3290_ VGND VGND VPWR VPWR _2148_ _0238_ _0237_ Nand_gate
X_2172_ VGND VGND VPWR VPWR _0051_ net61 inverter
X_2241_ VPWR VGND VGND VPWR _0787_ _0798_ net44 Xnor
XFILLER_0_25_9 VGND VGND VPWR VPWR sky130_fd_sc_hd__fill_2
XFILLER_0_28_285 VGND VGND VPWR VPWR sky130_fd_sc_hd__fill_1
XFILLER_0_7_113 VGND VGND VPWR VPWR sky130_fd_sc_hd__decap_8
X_3488_ VGND VGND VPWR VPWR _0453_ _0448_ _0451_ _1606_ Mux
X_2508_ VGND VGND VPWR VPWR _1617_ _1616_ inverter
X_3557_ VGND VGND VPWR VPWR _0489_ _0527_ _0526_ Nand_gate
X_3626_ VGND VGND VPWR VPWR _0566_ _0602_ _0601_ Nand_gate
XFILLER_0_47_90 VPWR VGND VPWR VGND sky130_ef_sc_hd__decap_12
X_2439_ VGND VGND VPWR VPWR _1548_ net18 inverter
X_4109_ VGND VGND VPWR VPWR _1124_ _0513_ _0512_ _1123_ Mux
XPHY_114 VGND VGND VPWR VPWR sky130_fd_sc_hd__decap_3
XPHY_103 VGND VGND VPWR VPWR sky130_fd_sc_hd__decap_3
XFILLER_0_19_274 VGND VGND VPWR VPWR sky130_fd_sc_hd__decap_6
XFILLER_0_19_252 VGND VGND VPWR VPWR sky130_fd_sc_hd__decap_6
XFILLER_0_19_296 VPWR VGND VPWR VGND sky130_ef_sc_hd__decap_12
XFILLER_0_57_314 VPWR VGND VPWR VGND sky130_ef_sc_hd__decap_12
XFILLER_0_43_48 VGND VGND VPWR VPWR sky130_fd_sc_hd__decap_8
XFILLER_0_43_15 VPWR VGND VPWR VGND sky130_ef_sc_hd__decap_12
XPHY_5 VGND VGND VPWR VPWR sky130_fd_sc_hd__decap_3
X_2790_ VGND VGND VPWR VPWR _1895_ _1817_ _1896_ Nor_gate
XFILLER_0_25_255 VGND VGND VPWR VPWR sky130_fd_sc_hd__fill_1
XFILLER_0_25_222 VGND VGND VPWR VPWR sky130_fd_sc_hd__fill_2
XFILLER_0_7_15 VPWR VGND VPWR VGND sky130_ef_sc_hd__decap_12
X_3342_ VGND VGND VPWR VPWR _0030_ _0294_ _0293_ Nand_gate
X_3411_ VGND VGND VPWR VPWR _1491_ _0369_ _0368_ Nand_gate
X_3273_ VPWR VGND VGND VPWR net3 _0219_ _0218_ Xnor
X_2224_ VGND VGND VPWR VPWR _0614_ net47 inverter
XFILLER_0_17_60 VGND VGND VPWR VPWR sky130_fd_sc_hd__decap_8
XFILLER_0_33_92 VGND VGND VPWR VPWR sky130_fd_sc_hd__decap_3
XFILLER_0_31_203 VGND VGND VPWR VPWR sky130_fd_sc_hd__decap_6
X_3609_ VGND VGND VPWR VPWR _0787_ net44 _0584_ Nor_gate
X_2988_ VGND VGND VPWR VPWR _2088_ _2091_ _2090_ Nand_gate
XFILLER_0_22_225 VGND VGND VPWR VPWR sky130_fd_sc_hd__fill_1
XFILLER_0_57_166 VGND VGND VPWR VPWR sky130_fd_sc_hd__fill_2
X_2911_ VGND VGND VPWR VPWR _2016_ _1441_ _2015_ _1605_ Mux
X_3960_ VGND VGND VPWR VPWR _0960_ _0962_ _0961_ Nand_gate
X_3891_ VGND VGND VPWR VPWR _0885_ _0887_ _0888_ Nor_gate
X_2842_ VGND VGND VPWR VPWR _1791_ _1947_ _1948_ Nor_gate
X_2773_ VGND VGND VPWR VPWR _1860_ _1880_ _1683_ Nand_gate
XFILLER_0_13_203 VGND VGND VPWR VPWR sky130_fd_sc_hd__fill_1
XTAP_475 VGND VPWR sky130_fd_sc_hd__tapvpwrvgnd_1
XTAP_464 VGND VPWR sky130_fd_sc_hd__tapvpwrvgnd_1
XTAP_453 VGND VPWR sky130_fd_sc_hd__tapvpwrvgnd_1
XTAP_442 VGND VPWR sky130_fd_sc_hd__tapvpwrvgnd_1
XTAP_431 VGND VPWR sky130_fd_sc_hd__tapvpwrvgnd_1
XTAP_420 VGND VPWR sky130_fd_sc_hd__tapvpwrvgnd_1
X_3256_ VGND VGND VPWR VPWR _0199_ _0201_ _0200_ Nand_gate
XFILLER_0_0_141 VGND VGND VPWR VPWR sky130_fd_sc_hd__fill_2
X_3325_ VGND VGND VPWR VPWR _0241_ _0276_ _0275_ Nand_gate
XFILLER_0_48_111 VGND VGND VPWR VPWR sky130_fd_sc_hd__fill_1
X_3187_ VGND VGND VPWR VPWR _1100_ _1684_ _0126_ Nor_gate
XFILLER_0_21_3 VGND VGND VPWR VPWR sky130_fd_sc_hd__decap_8
X_2207_ VGND VGND VPWR VPWR _0398_ _0419_ _0430_ Nor_gate
XFILLER_0_36_339 VGND VGND VPWR VPWR sky130_fd_sc_hd__fill_2
XFILLER_0_39_144 VGND VGND VPWR VPWR sky130_fd_sc_hd__fill_1
XFILLER_0_40_27 VGND VGND VPWR VPWR sky130_fd_sc_hd__fill_1
XFILLER_0_4_27 VGND VGND VPWR VPWR sky130_fd_sc_hd__fill_1
XFILLER_0_10_206 VGND VGND VPWR VPWR sky130_fd_sc_hd__decap_3
XFILLER_0_10_239 VGND VGND VPWR VPWR sky130_fd_sc_hd__decap_6
X_3110_ VGND VGND VPWR VPWR _0030_ _0039_ _0043_ Nor_gate
X_4090_ VGND VGND VPWR VPWR net19 _1103_ _1043_ Nand_gate
X_3041_ VGND VGND VPWR VPWR _1690_ _2143_ _2142_ Nand_gate
X_3943_ VGND VGND VPWR VPWR _1862_ _0943_ _0944_ Nor_gate
XFILLER_0_45_169 VGND VGND VPWR VPWR sky130_fd_sc_hd__fill_2
XFILLER_0_45_147 VGND VGND VPWR VPWR sky130_fd_sc_hd__fill_1
X_2825_ VGND VGND VPWR VPWR _1931_ _1927_ _1930_ _1419_ Mux
X_3874_ VPWR VGND VGND VPWR net51 _0869_ _0868_ Xnor
X_2687_ VGND VGND VPWR VPWR _1586_ _1794_ _1795_ Nor_gate
X_2756_ VGND VGND VPWR VPWR _1636_ _1862_ _1863_ Nor_gate
XFILLER_0_30_82 VGND VGND VPWR VPWR sky130_fd_sc_hd__fill_2
XFILLER_0_30_60 VGND VGND VPWR VPWR sky130_fd_sc_hd__fill_1
XFILLER_0_5_244 VGND VGND VPWR VPWR sky130_fd_sc_hd__fill_2
X_3308_ VGND VGND VPWR VPWR _0256_ _0258_ _0141_ Nand_gate
XTAP_294 VGND VPWR sky130_fd_sc_hd__tapvpwrvgnd_1
XTAP_283 VGND VPWR sky130_fd_sc_hd__tapvpwrvgnd_1
X_3239_ VGND VGND VPWR VPWR _1648_ _0182_ _0183_ Nor_gate
XTAP_272 VGND VPWR sky130_fd_sc_hd__tapvpwrvgnd_1
XTAP_261 VGND VPWR sky130_fd_sc_hd__tapvpwrvgnd_1
X_4288_ VGND VGND VPWR VPWR _1880_ _1317_ _1315_ Nand_gate
XTAP_250 VGND VPWR sky130_fd_sc_hd__tapvpwrvgnd_1
X_4357_ VGND VGND VPWR VPWR net77 _1389_ _1390_ Nor_gate
XFILLER_0_36_125 VGND VGND VPWR VPWR sky130_fd_sc_hd__fill_2
XFILLER_0_35_27 VGND VGND VPWR VPWR sky130_fd_sc_hd__fill_1
XFILLER_0_35_16 VGND VGND VPWR VPWR sky130_fd_sc_hd__fill_2
XFILLER_0_27_169 VGND VGND VPWR VPWR sky130_fd_sc_hd__fill_2
XFILLER_0_50_161 VGND VGND VPWR VPWR sky130_fd_sc_hd__decap_3
X_2610_ VGND VGND VPWR VPWR _1713_ _1718_ _1717_ Nand_gate
XFILLER_0_35_180 VGND VGND VPWR VPWR sky130_fd_sc_hd__decap_6
X_2541_ _1636_ VGND VGND VPWR VPWR _1650_ sky130_fd_sc_hd__buf_2
X_2472_ VGND VGND VPWR VPWR _0084_ _1581_ _1580_ Nand_gate
X_3590_ VGND VGND VPWR VPWR _0552_ _0563_ _0562_ Nand_gate
XFILLER_0_55_9 VPWR VGND VPWR VGND sky130_ef_sc_hd__decap_12
X_4142_ VGND VGND VPWR VPWR _1159_ _1158_ inverter
X_4073_ VGND VGND VPWR VPWR _0980_ _1032_ _1084_ Nor_gate
X_4211_ VGND VGND VPWR VPWR _1232_ _1233_ _1234_ Nor_gate
X_3024_ VGND VGND VPWR VPWR _2124_ _2127_ _2126_ Nand_gate
X_3857_ VGND VGND VPWR VPWR _0228_ _0850_ _0851_ Nor_gate
X_2808_ VGND VGND VPWR VPWR _1903_ _1913_ _1914_ Nor_gate
XFILLER_0_18_158 VGND VGND VPWR VPWR sky130_fd_sc_hd__fill_1
X_3788_ VGND VGND VPWR VPWR _0582_ _0777_ _0716_ Nand_gate
X_3926_ VGND VGND VPWR VPWR _0925_ _0924_ inverter
X_2739_ VGND VGND VPWR VPWR _1671_ _1846_ _1845_ Nand_gate
XFILLER_0_5_70 VGND VGND VPWR VPWR sky130_fd_sc_hd__fill_2
XFILLER_0_20_334 VGND VGND VPWR VPWR sky130_fd_sc_hd__fill_2
XFILLER_0_46_37 VGND VGND VPWR VPWR sky130_fd_sc_hd__fill_1
X_3711_ VGND VGND VPWR VPWR _0694_ _0959_ _1230_ _1608_ Mux
XFILLER_0_7_328 VGND VGND VPWR VPWR sky130_fd_sc_hd__decap_8
X_3642_ VGND VGND VPWR VPWR _0733_ _0619_ _0617_ Nand_gate
X_2524_ _1438_ VGND VGND VPWR VPWR _1633_ sky130_fd_sc_hd__clkbuf_4
XFILLER_0_23_183 VGND VGND VPWR VPWR sky130_fd_sc_hd__fill_2
X_2455_ VGND VGND VPWR VPWR _1562_ _1563_ _1564_ Nor_gate
X_3573_ VGND VGND VPWR VPWR _0543_ _0544_ _0480_ Nand_gate
XFILLER_0_11_323 VPWR VGND VPWR VGND sky130_ef_sc_hd__decap_12
X_4125_ VGND VGND VPWR VPWR _1139_ _1098_ _1140_ Nor_gate
X_4056_ VGND VGND VPWR VPWR _1548_ _1063_ _1066_ Nor_gate
X_2386_ VGND VGND VPWR VPWR _1494_ _1495_ net40 Nand_gate
X_3007_ VGND VGND VPWR VPWR _1648_ _2109_ _2110_ Nor_gate
X_3909_ VGND VGND VPWR VPWR _2119_ _0907_ _0908_ Nor_gate
XFILLER_0_14_150 VGND VGND VPWR VPWR sky130_fd_sc_hd__fill_2
XFILLER_0_14_161 VGND VGND VPWR VPWR sky130_fd_sc_hd__decap_8
XFILLER_0_4_309 VGND VGND VPWR VPWR sky130_fd_sc_hd__decap_6
XFILLER_0_57_25 VPWR VGND VPWR VGND sky130_ef_sc_hd__decap_12
XFILLER_0_20_164 VGND VGND VPWR VPWR sky130_fd_sc_hd__decap_6
XFILLER_0_57_69 VPWR VGND VPWR VGND sky130_ef_sc_hd__decap_12
X_2171_ VGND VGND VPWR VPWR _0040_ net25 inverter
XFILLER_0_20_197 VGND VGND VPWR VPWR sky130_fd_sc_hd__decap_8
X_2240_ net8 VGND VGND VPWR VPWR _0787_ sky130_fd_sc_hd__clkbuf_4
XFILLER_0_43_223 VGND VGND VPWR VPWR sky130_fd_sc_hd__fill_1
XFILLER_0_28_253 VGND VGND VPWR VPWR sky130_fd_sc_hd__decap_3
X_3625_ VGND VGND VPWR VPWR _0572_ _0600_ _0601_ Nor_gate
X_3487_ VGND VGND VPWR VPWR _0451_ _0330_ _0450_ _1938_ Mux
X_2438_ VGND VGND VPWR VPWR _1546_ _1547_ net55 Nand_gate
X_2507_ VGND VGND VPWR VPWR _1616_ _1428_ _1420_ _1615_ Mux
XFILLER_0_11_131 VGND VGND VPWR VPWR sky130_fd_sc_hd__fill_2
XFILLER_0_11_175 VGND VGND VPWR VPWR sky130_fd_sc_hd__decap_6
X_3556_ VGND VGND VPWR VPWR _0496_ _0525_ _0526_ Nor_gate
X_4108_ VGND VGND VPWR VPWR _1546_ _1121_ _1123_ Nor_gate
X_4039_ VGND VGND VPWR VPWR _1048_ _2147_ _0115_ _0738_ Mux
X_2369_ VGND VGND VPWR VPWR _1478_ net31 inverter
XPHY_115 VGND VGND VPWR VPWR sky130_fd_sc_hd__decap_3
XPHY_104 VGND VGND VPWR VPWR sky130_fd_sc_hd__decap_3
XFILLER_0_19_220 VGND VGND VPWR VPWR sky130_fd_sc_hd__decap_4
XFILLER_0_34_245 VGND VGND VPWR VPWR sky130_fd_sc_hd__decap_3
XFILLER_0_6_191 VGND VGND VPWR VPWR sky130_fd_sc_hd__fill_2
XFILLER_0_57_337 VGND VGND VPWR VPWR sky130_fd_sc_hd__decap_4
XFILLER_0_57_326 VGND VGND VPWR VPWR sky130_fd_sc_hd__decap_8
XFILLER_0_43_27 VGND VGND VPWR VPWR sky130_fd_sc_hd__decap_3
XPHY_6 VGND VGND VPWR VPWR sky130_fd_sc_hd__decap_3
XFILLER_0_4_139 VGND VGND VPWR VPWR sky130_fd_sc_hd__fill_1
XFILLER_0_4_128 VGND VGND VPWR VPWR sky130_fd_sc_hd__fill_2
XFILLER_0_7_27 VPWR VGND VPWR VGND sky130_ef_sc_hd__decap_12
X_3341_ VGND VGND VPWR VPWR _0166_ _0292_ _0293_ Nor_gate
X_3272_ VPWR VGND VGND VPWR net39 _0218_ _0217_ Xnor
X_3410_ VGND VGND VPWR VPWR _1494_ _0270_ _0368_ Nor_gate
X_2223_ VGND VGND VPWR VPWR _0603_ net11 inverter
X_2987_ VGND VGND VPWR VPWR _1898_ _2089_ _2090_ Nor_gate
X_3608_ VGND VGND VPWR VPWR _0583_ _0581_ inverter
X_3539_ VGND VGND VPWR VPWR _0499_ _0507_ _0508_ Nor_gate
XFILLER_0_39_337 VGND VGND VPWR VPWR sky130_fd_sc_hd__decap_8
XFILLER_0_38_27 VGND VGND VPWR VPWR sky130_fd_sc_hd__fill_1
XFILLER_0_22_259 VPWR VGND VPWR VGND sky130_ef_sc_hd__decap_12
XFILLER_0_54_15 VPWR VGND VPWR VGND sky130_ef_sc_hd__decap_12
XFILLER_0_57_189 VGND VGND VPWR VPWR sky130_fd_sc_hd__decap_4
XFILLER_0_57_178 VGND VGND VPWR VPWR sky130_fd_sc_hd__fill_2
XFILLER_0_57_156 VGND VGND VPWR VPWR sky130_fd_sc_hd__fill_1
X_2910_ VGND VGND VPWR VPWR _2015_ _2012_ _2014_ _1938_ Mux
X_2841_ VPWR VGND VGND VPWR _1428_ _1947_ _1420_ Xnor
X_3890_ VGND VGND VPWR VPWR _0676_ _0887_ _0886_ Nand_gate
X_2772_ VGND VGND VPWR VPWR _1713_ _1428_ _1879_ Nor_gate
XTAP_476 VGND VPWR sky130_fd_sc_hd__tapvpwrvgnd_1
XTAP_465 VGND VPWR sky130_fd_sc_hd__tapvpwrvgnd_1
XTAP_454 VGND VPWR sky130_fd_sc_hd__tapvpwrvgnd_1
XTAP_443 VGND VPWR sky130_fd_sc_hd__tapvpwrvgnd_1
XTAP_432 VGND VPWR sky130_fd_sc_hd__tapvpwrvgnd_1
XTAP_421 VGND VPWR sky130_fd_sc_hd__tapvpwrvgnd_1
X_3255_ VGND VGND VPWR VPWR _1866_ _0200_ _0141_ Nand_gate
XTAP_410 VGND VPWR sky130_fd_sc_hd__tapvpwrvgnd_1
XFILLER_0_0_153 VGND VGND VPWR VPWR sky130_fd_sc_hd__decap_8
XFILLER_0_0_197 VPWR VGND VPWR VGND sky130_ef_sc_hd__decap_12
X_2206_ VGND VGND VPWR VPWR _0419_ _0409_ inverter
X_3324_ VGND VGND VPWR VPWR _0250_ _0274_ _0275_ Nor_gate
XFILLER_0_44_70 VGND VGND VPWR VPWR sky130_fd_sc_hd__decap_3
X_3186_ VGND VGND VPWR VPWR net68 _0125_ _2002_ Nand_gate
XFILLER_0_48_189 VGND VGND VPWR VPWR sky130_fd_sc_hd__decap_3
XFILLER_0_39_167 VGND VGND VPWR VPWR sky130_fd_sc_hd__fill_1
XFILLER_0_39_123 VPWR VGND VPWR VGND sky130_ef_sc_hd__decap_12
XFILLER_0_24_29 VPWR VGND VPWR VGND sky130_ef_sc_hd__decap_12
XFILLER_0_50_321 VPWR VGND VPWR VGND sky130_ef_sc_hd__decap_12
X_3040_ VGND VGND VPWR VPWR _2137_ _2142_ _2140_ Nand_gate
X_3942_ VGND VGND VPWR VPWR _0229_ _0942_ _0943_ Nor_gate
X_2824_ VGND VGND VPWR VPWR _1930_ _1928_ _1929_ _1712_ Mux
XFILLER_0_18_318 VGND VGND VPWR VPWR sky130_fd_sc_hd__decap_4
X_3873_ VGND VGND VPWR VPWR _0355_ _0867_ _0868_ Nor_gate
X_2686_ VGND VGND VPWR VPWR _1607_ net12 _1794_ Nor_gate
XFILLER_0_41_321 VGND VGND VPWR VPWR sky130_fd_sc_hd__fill_2
X_2755_ _1861_ VGND VGND VPWR VPWR _1862_ sky130_fd_sc_hd__clkbuf_4
XFILLER_0_5_289 VGND VGND VPWR VPWR sky130_fd_sc_hd__decap_3
X_4356_ VGND VGND VPWR VPWR _1378_ _1389_ _1388_ Nand_gate
X_3307_ VGND VGND VPWR VPWR _0256_ _1795_ _1936_ _0255_ Mux
X_3169_ VGND VGND VPWR VPWR _0103_ _0107_ _0106_ Nand_gate
X_3238_ VGND VGND VPWR VPWR _0177_ _0180_ _0182_ Nor_gate
XTAP_295 VGND VPWR sky130_fd_sc_hd__tapvpwrvgnd_1
XTAP_284 VGND VPWR sky130_fd_sc_hd__tapvpwrvgnd_1
XTAP_273 VGND VPWR sky130_fd_sc_hd__tapvpwrvgnd_1
XTAP_262 VGND VPWR sky130_fd_sc_hd__tapvpwrvgnd_1
X_4287_ VGND VGND VPWR VPWR _1563_ _1315_ _0512_ Nand_gate
XTAP_251 VGND VPWR sky130_fd_sc_hd__tapvpwrvgnd_1
XTAP_240 VGND VPWR sky130_fd_sc_hd__tapvpwrvgnd_1
XFILLER_0_51_107 VGND VGND VPWR VPWR sky130_fd_sc_hd__decap_4
XFILLER_0_36_148 VGND VGND VPWR VPWR sky130_fd_sc_hd__decap_6
XFILLER_0_36_137 VGND VGND VPWR VPWR sky130_fd_sc_hd__decap_3
XFILLER_0_32_321 VPWR VGND VPWR VGND sky130_ef_sc_hd__decap_12
XFILLER_0_3_3 VPWR VGND VPWR VGND sky130_ef_sc_hd__decap_12
XFILLER_0_50_173 VPWR VGND VPWR VGND sky130_ef_sc_hd__decap_12
X_2540_ VGND VGND VPWR VPWR _1644_ _1649_ _1648_ Nand_gate
X_4210_ VGND VGND VPWR VPWR _1227_ _0001_ _1233_ Nor_gate
XFILLER_0_23_321 VGND VGND VPWR VPWR sky130_fd_sc_hd__decap_6
X_2471_ VGND VGND VPWR VPWR _1505_ _1580_ _1579_ Nand_gate
X_4141_ VGND VGND VPWR VPWR _1158_ _0259_ _1157_ _0738_ Mux
X_4072_ VPWR VGND VGND VPWR _1546_ _1083_ _1082_ Xnor
X_3023_ VGND VGND VPWR VPWR _1791_ _2125_ _2126_ Nor_gate
X_3925_ VGND VGND VPWR VPWR _0333_ _0924_ _0869_ Nand_gate
X_3856_ VGND VGND VPWR VPWR _0847_ _0849_ _0850_ Nor_gate
X_2738_ VGND VGND VPWR VPWR _1845_ _1841_ _1844_ _1633_ Mux
X_2807_ VGND VGND VPWR VPWR _1427_ _0040_ _1913_ Nor_gate
XFILLER_0_26_181 VGND VGND VPWR VPWR sky130_fd_sc_hd__decap_4
X_3787_ VGND VGND VPWR VPWR _0582_ _0716_ _0775_ Nor_gate
XFILLER_0_14_332 VGND VGND VPWR VPWR sky130_fd_sc_hd__decap_8
X_2669_ VGND VGND VPWR VPWR _1646_ _1680_ _1777_ Nor_gate
X_4339_ VGND VGND VPWR VPWR _1179_ _1371_ _1283_ Nand_gate
XFILLER_0_1_281 VPWR VGND VPWR VGND sky130_ef_sc_hd__decap_12
XFILLER_0_24_107 VGND VGND VPWR VPWR sky130_fd_sc_hd__decap_8
XFILLER_0_46_27 VGND VGND VPWR VPWR sky130_fd_sc_hd__fill_1
X_3710_ VGND VGND VPWR VPWR _0686_ _0692_ _0693_ Nor_gate
X_3572_ VGND VGND VPWR VPWR _0543_ _1014_ inverter
X_3641_ VGND VGND VPWR VPWR _0733_ _0617_ _0618_ Nor_gate
XFILLER_0_15_107 VGND VGND VPWR VPWR sky130_fd_sc_hd__decap_4
XFILLER_0_15_129 VGND VGND VPWR VPWR sky130_fd_sc_hd__fill_2
X_2523_ VGND VGND VPWR VPWR _1632_ _1630_ _1631_ _1628_ Mux
X_2385_ VGND VGND VPWR VPWR _1494_ net4 inverter
X_2454_ VGND VGND VPWR VPWR _1563_ _0127_ inverter
XFILLER_0_11_335 VGND VGND VPWR VPWR sky130_fd_sc_hd__fill_1
Xinput1 a[0] VGND VGND VPWR VPWR net1 sky130_fd_sc_hd__clkbuf_2
X_3006_ VGND VGND VPWR VPWR _2107_ _2108_ _2109_ Nor_gate
XFILLER_0_36_60 VGND VGND VPWR VPWR sky130_fd_sc_hd__decap_8
X_4124_ VGND VGND VPWR VPWR _1546_ _1082_ _1139_ Nor_gate
X_4055_ VGND VGND VPWR VPWR net18 net54 _1065_ Nor_gate
X_3908_ VGND VGND VPWR VPWR _0907_ _0905_ inverter
X_3839_ VGND VGND VPWR VPWR _0828_ _0831_ _0832_ Nor_gate
XFILLER_0_14_184 VGND VGND VPWR VPWR sky130_fd_sc_hd__decap_3
XFILLER_0_37_276 VGND VGND VPWR VPWR sky130_fd_sc_hd__decap_4
XFILLER_0_57_37 VPWR VGND VPWR VGND sky130_ef_sc_hd__decap_12
XFILLER_0_52_279 VGND VGND VPWR VPWR sky130_fd_sc_hd__decap_3
XFILLER_0_20_154 VGND VGND VPWR VPWR sky130_fd_sc_hd__fill_1
X_2170_ VGND VGND VPWR VPWR net25 _0029_ net61 Nand_gate
XFILLER_0_28_265 VPWR VGND VPWR VGND sky130_ef_sc_hd__decap_12
XFILLER_0_28_232 VGND VGND VPWR VPWR sky130_fd_sc_hd__fill_1
XFILLER_0_7_126 VGND VGND VPWR VPWR sky130_fd_sc_hd__fill_2
XFILLER_0_43_279 VGND VGND VPWR VPWR sky130_fd_sc_hd__fill_1
X_3624_ VGND VGND VPWR VPWR _0583_ _0600_ _0599_ Nand_gate
X_3555_ VGND VGND VPWR VPWR _0510_ _0525_ _0524_ Nand_gate
XFILLER_0_3_321 VPWR VGND VPWR VGND sky130_ef_sc_hd__decap_12
X_3486_ VGND VGND VPWR VPWR _0450_ _0449_ inverter
X_2506_ net37 VGND VGND VPWR VPWR _1615_ sky130_fd_sc_hd__buf_4
XFILLER_0_47_70 VGND VGND VPWR VPWR sky130_fd_sc_hd__decap_4
X_2437_ VGND VGND VPWR VPWR _1546_ net19 inverter
X_2368_ VGND VGND VPWR VPWR _1475_ _1476_ _1477_ Nor_gate
XPHY_116 VGND VGND VPWR VPWR sky130_fd_sc_hd__decap_3
XPHY_105 VGND VGND VPWR VPWR sky130_fd_sc_hd__decap_3
X_4107_ VGND VGND VPWR VPWR _1121_ net55 inverter
X_4038_ VGND VGND VPWR VPWR _1041_ _1045_ _1047_ Nor_gate
X_2299_ VGND VGND VPWR VPWR _1402_ _1408_ _1407_ Nand_gate
XFILLER_0_2_83 VGND VGND VPWR VPWR sky130_fd_sc_hd__fill_1
XPHY_7 VGND VGND VPWR VPWR sky130_fd_sc_hd__decap_3
XFILLER_0_25_279 VGND VGND VPWR VPWR sky130_fd_sc_hd__fill_1
XFILLER_0_25_213 VGND VGND VPWR VPWR sky130_fd_sc_hd__decap_6
XFILLER_0_4_107 VGND VGND VPWR VPWR sky130_fd_sc_hd__decap_3
XFILLER_0_7_39 VPWR VGND VPWR VGND sky130_ef_sc_hd__decap_12
X_3340_ VGND VGND VPWR VPWR _0292_ _0291_ inverter
X_3271_ VGND VGND VPWR VPWR _0154_ _0217_ _0216_ Nand_gate
X_2222_ VGND VGND VPWR VPWR _0582_ _0593_ net47 Nand_gate
XFILLER_0_30_9 VGND VGND VPWR VPWR sky130_fd_sc_hd__fill_1
XFILLER_0_17_51 VGND VGND VPWR VPWR sky130_fd_sc_hd__fill_1
X_2986_ VGND VGND VPWR VPWR _2074_ _2087_ _2089_ Nor_gate
X_3538_ VGND VGND VPWR VPWR _1862_ _0505_ _0507_ Nor_gate
X_3607_ VGND VGND VPWR VPWR _1982_ _0580_ _0581_ Nor_gate
X_3469_ VGND VGND VPWR VPWR _0427_ _0431_ _0432_ Nor_gate
XFILLER_0_22_205 VGND VGND VPWR VPWR sky130_fd_sc_hd__fill_1
XFILLER_0_30_282 VGND VGND VPWR VPWR sky130_fd_sc_hd__fill_1
XFILLER_0_54_27 VGND VGND VPWR VPWR sky130_fd_sc_hd__fill_1
XFILLER_0_57_124 VGND VGND VPWR VPWR sky130_fd_sc_hd__decap_3
XFILLER_0_57_113 VGND VGND VPWR VPWR sky130_fd_sc_hd__fill_2
X_2771_ VGND VGND VPWR VPWR _1428_ _1791_ _1878_ Nor_gate
X_2840_ VGND VGND VPWR VPWR _1943_ _1945_ _1946_ Nor_gate
XTAP_400 VGND VPWR sky130_fd_sc_hd__tapvpwrvgnd_1
X_4372_ _1406_ VGND VGND VPWR VPWR net101 sky130_fd_sc_hd__clkbuf_1
XFILLER_0_0_121 VGND VGND VPWR VPWR sky130_fd_sc_hd__fill_1
XTAP_477 VGND VPWR sky130_fd_sc_hd__tapvpwrvgnd_1
XTAP_466 VGND VPWR sky130_fd_sc_hd__tapvpwrvgnd_1
XTAP_455 VGND VPWR sky130_fd_sc_hd__tapvpwrvgnd_1
XTAP_444 VGND VPWR sky130_fd_sc_hd__tapvpwrvgnd_1
XTAP_433 VGND VPWR sky130_fd_sc_hd__tapvpwrvgnd_1
X_3254_ VGND VGND VPWR VPWR _1726_ _0199_ _0198_ Nand_gate
XTAP_422 VGND VPWR sky130_fd_sc_hd__tapvpwrvgnd_1
XTAP_411 VGND VPWR sky130_fd_sc_hd__tapvpwrvgnd_1
X_2205_ VGND VGND VPWR VPWR _0387_ _0409_ net50 Nand_gate
X_3185_ VGND VGND VPWR VPWR _0121_ _0123_ _0124_ Nor_gate
X_3323_ VGND VGND VPWR VPWR _0274_ _0273_ inverter
XFILLER_0_48_157 VGND VGND VPWR VPWR sky130_fd_sc_hd__fill_2
XFILLER_0_48_124 VGND VGND VPWR VPWR sky130_fd_sc_hd__decap_3
XFILLER_0_44_82 VGND VGND VPWR VPWR sky130_fd_sc_hd__fill_2
XFILLER_0_44_60 VGND VGND VPWR VPWR sky130_fd_sc_hd__fill_1
XFILLER_0_8_221 VGND VGND VPWR VPWR sky130_fd_sc_hd__decap_6
X_2969_ VGND VGND VPWR VPWR _1813_ _2071_ _2072_ Nor_gate
XFILLER_0_8_93 VGND VGND VPWR VPWR sky130_fd_sc_hd__fill_2
XFILLER_0_39_135 VGND VGND VPWR VPWR sky130_fd_sc_hd__fill_2
XFILLER_0_39_113 VGND VGND VPWR VPWR sky130_fd_sc_hd__fill_1
XFILLER_0_40_29 VGND VGND VPWR VPWR sky130_fd_sc_hd__decap_4
XFILLER_0_35_341 VGND VGND VPWR VPWR sky130_fd_sc_hd__fill_2
XFILLER_0_50_333 VPWR VGND VPWR VGND sky130_ef_sc_hd__decap_12
XFILLER_0_4_29 VPWR VGND VPWR VGND sky130_ef_sc_hd__decap_12
X_3941_ VGND VGND VPWR VPWR _0942_ _0735_ _0941_ _0379_ Mux
X_2823_ VGND VGND VPWR VPWR _1929_ _1737_ _1731_ _1432_ Mux
XFILLER_0_45_127 VGND VGND VPWR VPWR sky130_fd_sc_hd__decap_6
X_2754_ VGND VGND VPWR VPWR _1642_ _1861_ _1860_ Nand_gate
XFILLER_0_5_279 VGND VGND VPWR VPWR sky130_fd_sc_hd__fill_1
X_3872_ VGND VGND VPWR VPWR _0760_ _0866_ _0867_ Nor_gate
X_3306_ _2155_ VGND VGND VPWR VPWR _0255_ sky130_fd_sc_hd__clkbuf_4
XFILLER_0_39_60 VPWR VGND VPWR VGND sky130_ef_sc_hd__decap_12
X_2685_ VGND VGND VPWR VPWR _1788_ _1792_ _1793_ Nor_gate
XFILLER_0_30_95 VGND VGND VPWR VPWR sky130_fd_sc_hd__fill_1
XTAP_241 VGND VPWR sky130_fd_sc_hd__tapvpwrvgnd_1
X_4355_ VGND VGND VPWR VPWR net76 _1387_ _1388_ Nor_gate
XTAP_230 VGND VPWR sky130_fd_sc_hd__tapvpwrvgnd_1
X_3168_ VGND VGND VPWR VPWR _1650_ _0104_ _0106_ Nor_gate
X_3237_ VGND VGND VPWR VPWR _2000_ _0179_ _0180_ Nor_gate
XTAP_296 VGND VPWR sky130_fd_sc_hd__tapvpwrvgnd_1
XTAP_285 VGND VPWR sky130_fd_sc_hd__tapvpwrvgnd_1
XTAP_274 VGND VPWR sky130_fd_sc_hd__tapvpwrvgnd_1
X_4286_ VGND VGND VPWR VPWR _1563_ _1873_ _1314_ Nor_gate
XTAP_263 VGND VPWR sky130_fd_sc_hd__tapvpwrvgnd_1
XTAP_252 VGND VPWR sky130_fd_sc_hd__tapvpwrvgnd_1
XFILLER_0_36_105 VGND VGND VPWR VPWR sky130_fd_sc_hd__fill_2
X_3099_ VGND VGND VPWR VPWR net66 net65 _0031_ Nor_gate
XFILLER_0_32_333 VGND VGND VPWR VPWR sky130_fd_sc_hd__decap_4
XFILLER_0_42_119 VGND VGND VPWR VPWR sky130_fd_sc_hd__fill_1
XFILLER_0_27_149 VGND VGND VPWR VPWR sky130_fd_sc_hd__fill_1
XFILLER_0_23_333 VGND VGND VPWR VPWR sky130_fd_sc_hd__decap_3
XFILLER_0_23_311 VGND VGND VPWR VPWR sky130_fd_sc_hd__fill_1
X_4140_ VGND VGND VPWR VPWR _1157_ _0736_ _1156_ _0135_ Mux
XFILLER_0_50_141 VGND VGND VPWR VPWR sky130_fd_sc_hd__decap_4
X_2470_ VGND VGND VPWR VPWR _1543_ _1578_ _1579_ Nor_gate
X_4071_ VPWR VGND VGND VPWR net55 _1082_ _1081_ Xnor
X_3022_ VGND VGND VPWR VPWR _1380_ _2060_ _2125_ Nor_gate
XFILLER_0_41_50 VGND VGND VPWR VPWR sky130_fd_sc_hd__decap_3
X_3924_ VPWR VGND VGND VPWR net16 _0923_ _0922_ Xnor
X_3855_ VGND VGND VPWR VPWR _0594_ _0849_ _0848_ Nand_gate
X_2737_ VGND VGND VPWR VPWR _1753_ _1844_ _1843_ Nand_gate
X_2668_ VGND VGND VPWR VPWR _1766_ _1776_ _1775_ Nand_gate
X_2806_ VGND VGND VPWR VPWR _1765_ _1911_ _1912_ Nor_gate
X_3786_ VGND VGND VPWR VPWR _0771_ _0773_ _0774_ Nor_gate
X_2599_ VGND VGND VPWR VPWR _1697_ _1707_ _1708_ Nor_gate
X_4338_ _1369_ VGND VGND VPWR VPWR net93 sky130_fd_sc_hd__dlymetal6s2s_1
X_4269_ VGND VGND VPWR VPWR _0042_ _1295_ _1296_ Nor_gate
XFILLER_0_1_293 VPWR VGND VPWR VGND sky130_ef_sc_hd__decap_12
X_2522_ VGND VGND VPWR VPWR _1631_ net6 net7 _1615_ Mux
X_3571_ VGND VGND VPWR VPWR _0427_ _0542_ _0539_ Nand_gate
X_3640_ VGND VGND VPWR VPWR _1518_ _0493_ _0617_ Nor_gate
XFILLER_0_11_31 VGND VGND VPWR VPWR sky130_fd_sc_hd__decap_8
XFILLER_0_11_86 VGND VGND VPWR VPWR sky130_fd_sc_hd__fill_2
XFILLER_0_11_314 VGND VGND VPWR VPWR sky130_fd_sc_hd__fill_1
X_4123_ VPWR VGND VGND VPWR net20 _1138_ _1137_ Xnor
X_2453_ VGND VGND VPWR VPWR net24 net60 _1562_ Nor_gate
X_2384_ VGND VGND VPWR VPWR _1491_ _1492_ _1493_ Nor_gate
Xinput2 a[10] VGND VGND VPWR VPWR net2 sky130_fd_sc_hd__clkbuf_4
X_3005_ VGND VGND VPWR VPWR _1843_ _1993_ _2108_ Nor_gate
X_4054_ VGND VGND VPWR VPWR _1063_ _0001_ _1064_ Nor_gate
X_3907_ VGND VGND VPWR VPWR _0228_ _0904_ _0905_ Nor_gate
X_3838_ VGND VGND VPWR VPWR _0676_ _0831_ _0829_ Nand_gate
X_3769_ VGND VGND VPWR VPWR net79 _0756_ inverter
XFILLER_0_52_203 VGND VGND VPWR VPWR sky130_fd_sc_hd__fill_1
XFILLER_0_20_177 VGND VGND VPWR VPWR sky130_fd_sc_hd__fill_1
XFILLER_0_43_225 VGND VGND VPWR VPWR sky130_fd_sc_hd__decap_3
XFILLER_0_28_299 VGND VGND VPWR VPWR sky130_fd_sc_hd__fill_1
XFILLER_0_28_277 VGND VGND VPWR VPWR sky130_fd_sc_hd__decap_8
XFILLER_0_22_85 VGND VGND VPWR VPWR sky130_fd_sc_hd__decap_6
XFILLER_0_7_149 VPWR VGND VPWR VGND sky130_ef_sc_hd__decap_12
X_3485_ VGND VGND VPWR VPWR _0449_ _0852_ _1491_ _1607_ Mux
X_2505_ _1424_ VGND VGND VPWR VPWR _1614_ sky130_fd_sc_hd__clkbuf_4
X_3623_ VGND VGND VPWR VPWR _0590_ _0598_ _0599_ Nor_gate
X_3554_ VGND VGND VPWR VPWR _0516_ _0523_ _0524_ Nor_gate
XFILLER_0_3_344 VGND VGND VPWR VPWR sky130_fd_sc_hd__decap_3
XFILLER_0_3_333 VGND VGND VPWR VPWR sky130_fd_sc_hd__decap_3
X_2436_ VGND VGND VPWR VPWR _1544_ _1545_ net56 Nand_gate
XFILLER_0_37_3 VGND VGND VPWR VPWR sky130_fd_sc_hd__fill_2
X_4106_ VGND VGND VPWR VPWR net19 net55 _1120_ Nor_gate
X_2298_ VGND VGND VPWR VPWR net29 _1407_ net65 Nand_gate
X_2367_ VGND VGND VPWR VPWR _1476_ net68 inverter
XPHY_117 VGND VGND VPWR VPWR sky130_fd_sc_hd__decap_3
XPHY_106 VGND VGND VPWR VPWR sky130_fd_sc_hd__decap_3
X_4037_ VGND VGND VPWR VPWR _1045_ _1044_ inverter
XFILLER_0_34_203 VGND VGND VPWR VPWR sky130_fd_sc_hd__fill_1
XFILLER_0_19_244 VGND VGND VPWR VPWR sky130_fd_sc_hd__fill_1
XFILLER_0_25_203 VGND VGND VPWR VPWR sky130_fd_sc_hd__fill_1
XPHY_8 VGND VGND VPWR VPWR sky130_fd_sc_hd__decap_3
XFILLER_0_0_303 VGND VGND VPWR VPWR sky130_fd_sc_hd__decap_4
X_2221_ net11 VGND VGND VPWR VPWR _0582_ sky130_fd_sc_hd__clkbuf_4
X_3270_ VGND VGND VPWR VPWR net38 _0216_ _0215_ Nand_gate
XFILLER_0_33_84 VGND VGND VPWR VPWR sky130_fd_sc_hd__decap_8
XFILLER_0_33_73 VGND VGND VPWR VPWR sky130_fd_sc_hd__fill_2
X_2985_ VGND VGND VPWR VPWR _2074_ _2088_ _2087_ Nand_gate
X_3537_ VGND VGND VPWR VPWR _0505_ _2158_ _0504_ _1614_ Mux
X_3606_ VGND VGND VPWR VPWR _0573_ _0579_ _0580_ Nor_gate
Xinput60 b[30] VGND VGND VPWR VPWR net60 sky130_fd_sc_hd__clkbuf_2
X_3468_ VGND VGND VPWR VPWR _0428_ _0429_ _0431_ Nor_gate
X_3399_ VGND VGND VPWR VPWR _0356_ _0282_ inverter
X_2419_ VGND VGND VPWR VPWR net16 _1527_ _1528_ Nor_gate
XFILLER_0_54_309 VPWR VGND VPWR VGND sky130_ef_sc_hd__decap_12
XFILLER_0_22_239 VGND VGND VPWR VPWR sky130_fd_sc_hd__fill_1
XFILLER_0_15_291 VGND VGND VPWR VPWR sky130_fd_sc_hd__fill_1
XFILLER_0_38_29 VPWR VGND VPWR VGND sky130_ef_sc_hd__decap_12
XFILLER_0_30_294 VGND VGND VPWR VPWR sky130_fd_sc_hd__fill_2
XFILLER_0_57_136 VGND VGND VPWR VPWR sky130_fd_sc_hd__fill_2
X_2770_ VGND VGND VPWR VPWR _1874_ _1876_ _1877_ Nor_gate
XTAP_423 VGND VPWR sky130_fd_sc_hd__tapvpwrvgnd_1
XTAP_412 VGND VPWR sky130_fd_sc_hd__tapvpwrvgnd_1
XTAP_401 VGND VPWR sky130_fd_sc_hd__tapvpwrvgnd_1
X_4371_ VGND VGND VPWR VPWR net93 _1405_ _1406_ Nor_gate
XFILLER_0_21_294 VGND VGND VPWR VPWR sky130_fd_sc_hd__fill_1
XFILLER_0_0_177 VGND VGND VPWR VPWR sky130_fd_sc_hd__fill_1
XFILLER_0_13_228 VPWR VGND VPWR VGND sky130_ef_sc_hd__decap_12
X_3322_ VGND VGND VPWR VPWR _0266_ _0272_ _0273_ Nor_gate
XTAP_478 VGND VPWR sky130_fd_sc_hd__tapvpwrvgnd_1
XTAP_467 VGND VPWR sky130_fd_sc_hd__tapvpwrvgnd_1
XTAP_456 VGND VPWR sky130_fd_sc_hd__tapvpwrvgnd_1
XTAP_445 VGND VPWR sky130_fd_sc_hd__tapvpwrvgnd_1
X_3253_ VGND VGND VPWR VPWR _0198_ _2093_ _0197_ _1605_ Mux
XTAP_434 VGND VPWR sky130_fd_sc_hd__tapvpwrvgnd_1
XFILLER_0_28_95 VGND VGND VPWR VPWR sky130_fd_sc_hd__fill_1
XFILLER_0_28_73 VGND VGND VPWR VPWR sky130_fd_sc_hd__decap_4
XFILLER_0_28_51 VGND VGND VPWR VPWR sky130_fd_sc_hd__decap_8
XFILLER_0_28_40 VGND VGND VPWR VPWR sky130_fd_sc_hd__decap_3
X_2204_ VGND VGND VPWR VPWR _0387_ net50 _0398_ Nor_gate
X_3184_ VGND VGND VPWR VPWR _1705_ _0123_ _0122_ Nand_gate
XFILLER_0_48_147 VGND VGND VPWR VPWR sky130_fd_sc_hd__fill_1
X_2899_ VGND VGND VPWR VPWR _1999_ _2004_ _2003_ Nand_gate
X_2968_ VGND VGND VPWR VPWR _1699_ _2070_ _2071_ Nor_gate
XFILLER_0_54_139 VGND VGND VPWR VPWR sky130_fd_sc_hd__fill_1
XFILLER_0_50_301 VGND VGND VPWR VPWR sky130_fd_sc_hd__decap_6
XFILLER_0_50_345 VGND VGND VPWR VPWR sky130_fd_sc_hd__fill_2
X_3940_ VGND VGND VPWR VPWR _0941_ _0844_ _0940_ _0255_ Mux
XFILLER_0_45_117 VGND VGND VPWR VPWR sky130_fd_sc_hd__fill_1
X_3871_ VGND VGND VPWR VPWR _0866_ _0865_ inverter
X_2822_ VGND VGND VPWR VPWR _1928_ _1728_ _1730_ _1716_ Mux
XFILLER_0_41_345 VGND VGND VPWR VPWR sky130_fd_sc_hd__fill_2
XFILLER_0_41_334 VGND VGND VPWR VPWR sky130_fd_sc_hd__fill_2
XFILLER_0_38_180 VGND VGND VPWR VPWR sky130_fd_sc_hd__fill_2
X_2684_ VGND VGND VPWR VPWR _1430_ _1791_ _1792_ Nor_gate
XFILLER_0_30_85 VGND VGND VPWR VPWR sky130_fd_sc_hd__decap_3
XFILLER_0_30_74 VGND VGND VPWR VPWR sky130_fd_sc_hd__decap_8
X_2753_ VGND VGND VPWR VPWR net34 _1691_ _1860_ Nor_gate
XFILLER_0_5_225 VGND VGND VPWR VPWR sky130_fd_sc_hd__decap_4
XFILLER_0_5_269 VGND VGND VPWR VPWR sky130_fd_sc_hd__fill_1
X_3305_ VGND VGND VPWR VPWR _1614_ _0254_ _0253_ Nand_gate
XFILLER_0_39_72 VGND VGND VPWR VPWR sky130_fd_sc_hd__fill_1
X_4285_ VGND VGND VPWR VPWR _0113_ _1312_ _1313_ Nor_gate
XTAP_275 VGND VPWR sky130_fd_sc_hd__tapvpwrvgnd_1
XTAP_264 VGND VPWR sky130_fd_sc_hd__tapvpwrvgnd_1
XTAP_253 VGND VPWR sky130_fd_sc_hd__tapvpwrvgnd_1
XTAP_242 VGND VPWR sky130_fd_sc_hd__tapvpwrvgnd_1
X_4354_ VGND VGND VPWR VPWR _1383_ _1387_ _1386_ Nand_gate
XTAP_220 VGND VPWR sky130_fd_sc_hd__tapvpwrvgnd_1
XTAP_231 VGND VPWR sky130_fd_sc_hd__tapvpwrvgnd_1
XFILLER_0_55_82 VGND VGND VPWR VPWR sky130_fd_sc_hd__decap_6
X_3167_ VGND VGND VPWR VPWR _1625_ _1733_ _0104_ Nor_gate
X_3236_ VGND VGND VPWR VPWR _1614_ _0179_ _0178_ Nand_gate
XTAP_297 VGND VPWR sky130_fd_sc_hd__tapvpwrvgnd_1
XTAP_286 VGND VPWR sky130_fd_sc_hd__tapvpwrvgnd_1
X_3098_ VGND VGND VPWR VPWR _0016_ _0030_ _0028_ Nand_gate
XFILLER_0_44_194 VGND VGND VPWR VPWR sky130_fd_sc_hd__fill_2
XFILLER_0_44_183 VGND VGND VPWR VPWR sky130_fd_sc_hd__decap_4
XFILLER_0_27_117 VGND VGND VPWR VPWR sky130_fd_sc_hd__fill_1
XFILLER_0_35_194 VPWR VGND VPWR VGND sky130_ef_sc_hd__decap_12
XFILLER_0_2_217 VGND VGND VPWR VPWR sky130_fd_sc_hd__fill_1
XFILLER_0_50_197 VGND VGND VPWR VPWR sky130_fd_sc_hd__fill_2
X_4070_ VGND VGND VPWR VPWR _0977_ _1080_ _1081_ Nor_gate
X_3021_ VGND VGND VPWR VPWR _1380_ _2124_ _2060_ Nand_gate
X_3854_ VGND VGND VPWR VPWR _0229_ _0848_ _0406_ Nand_gate
X_2805_ VGND VGND VPWR VPWR _1904_ _1911_ _1910_ Nand_gate
XFILLER_0_25_85 VPWR VGND VPWR VGND sky130_ef_sc_hd__decap_12
XFILLER_0_18_139 VGND VGND VPWR VPWR sky130_fd_sc_hd__fill_1
X_3923_ VPWR VGND VGND VPWR _1527_ _0922_ _0921_ Xnor
X_2736_ VGND VGND VPWR VPWR _1432_ _1843_ _1842_ Nand_gate
XFILLER_0_41_153 VGND VGND VPWR VPWR sky130_fd_sc_hd__decap_3
X_2667_ VGND VGND VPWR VPWR _1736_ _1775_ _1774_ Nand_gate
XFILLER_0_26_194 VGND VGND VPWR VPWR sky130_fd_sc_hd__fill_2
XFILLER_0_26_161 VGND VGND VPWR VPWR sky130_fd_sc_hd__decap_8
X_3785_ VGND VGND VPWR VPWR _0773_ _0772_ inverter
XFILLER_0_1_261 VPWR VGND VPWR VGND sky130_ef_sc_hd__decap_12
X_2598_ VGND VGND VPWR VPWR _1434_ _1706_ _1707_ Nor_gate
X_4337_ VGND VGND VPWR VPWR _1339_ _1369_ _1368_ Nand_gate
X_4268_ VGND VGND VPWR VPWR _1288_ _1292_ _1295_ Nor_gate
X_3219_ VGND VGND VPWR VPWR _2084_ _0160_ _0161_ Nor_gate
XFILLER_0_5_62 VGND VGND VPWR VPWR sky130_fd_sc_hd__decap_8
XFILLER_0_5_51 VGND VGND VPWR VPWR sky130_fd_sc_hd__decap_4
XFILLER_0_49_231 VGND VGND VPWR VPWR sky130_fd_sc_hd__decap_3
X_4199_ VGND VGND VPWR VPWR _1213_ _1221_ _1220_ Nand_gate
XFILLER_0_32_120 VGND VGND VPWR VPWR sky130_fd_sc_hd__fill_1
XFILLER_0_17_172 VPWR VGND VPWR VGND sky130_ef_sc_hd__decap_12
XFILLER_0_20_326 VGND VGND VPWR VPWR sky130_fd_sc_hd__decap_4
XFILLER_0_46_29 VGND VGND VPWR VPWR sky130_fd_sc_hd__decap_8
XFILLER_0_55_223 VGND VGND VPWR VPWR sky130_fd_sc_hd__fill_1
XFILLER_0_7_309 VGND VGND VPWR VPWR sky130_fd_sc_hd__fill_1
X_2521_ VGND VGND VPWR VPWR _1630_ _0959_ _1491_ _1615_ Mux
XFILLER_0_23_164 VGND VGND VPWR VPWR sky130_fd_sc_hd__fill_1
XFILLER_0_23_153 VGND VGND VPWR VPWR sky130_fd_sc_hd__fill_2
X_3570_ VGND VGND VPWR VPWR _0306_ _0540_ _0541_ Nor_gate
XFILLER_0_11_98 VGND VGND VPWR VPWR sky130_fd_sc_hd__fill_1
XFILLER_0_11_337 VGND VGND VPWR VPWR sky130_fd_sc_hd__decap_6
XFILLER_0_39_7 VPWR VGND VPWR VGND sky130_ef_sc_hd__decap_12
X_4122_ VPWR VGND VGND VPWR net56 _1137_ _1136_ Xnor
X_4053_ VGND VGND VPWR VPWR _1063_ net54 inverter
X_2452_ VGND VGND VPWR VPWR net24 _0105_ _1561_ Nor_gate
X_2383_ VGND VGND VPWR VPWR _1492_ net41 inverter
Xinput3 a[11] VGND VGND VPWR VPWR net3 sky130_fd_sc_hd__buf_2
X_3004_ VGND VGND VPWR VPWR _1419_ _2106_ _2107_ Nor_gate
X_3906_ VGND VGND VPWR VPWR _0901_ _0903_ _0904_ Nor_gate
X_3837_ VGND VGND VPWR VPWR _0825_ _0829_ _0827_ Nand_gate
X_3768_ VGND VGND VPWR VPWR _0724_ _0754_ _0756_ Nor_gate
X_2719_ VGND VGND VPWR VPWR _1624_ _1825_ _1826_ Nor_gate
X_3699_ VGND VGND VPWR VPWR _0744_ _0569_ _0681_ Nor_gate
XFILLER_0_37_245 VGND VGND VPWR VPWR sky130_fd_sc_hd__decap_4
XFILLER_0_20_123 VGND VGND VPWR VPWR sky130_fd_sc_hd__decap_6
XFILLER_0_43_248 VGND VGND VPWR VPWR sky130_fd_sc_hd__fill_1
XFILLER_0_28_245 VGND VGND VPWR VPWR sky130_fd_sc_hd__decap_6
X_3622_ VGND VGND VPWR VPWR _0591_ _0598_ _0597_ Nand_gate
X_3484_ VGND VGND VPWR VPWR _0448_ _0197_ inverter
XFILLER_0_51_281 VGND VGND VPWR VPWR sky130_fd_sc_hd__decap_4
X_2504_ VGND VGND VPWR VPWR _1606_ _1612_ _1613_ Nor_gate
X_2435_ VGND VGND VPWR VPWR _1544_ net20 inverter
X_3553_ VGND VGND VPWR VPWR _0518_ _0523_ _0522_ Nand_gate
XFILLER_0_11_156 VPWR VGND VPWR VGND sky130_ef_sc_hd__decap_12
X_4105_ VGND VGND VPWR VPWR net55 _1119_ _0393_ Nand_gate
X_4036_ VGND VGND VPWR VPWR _0370_ _1043_ _1044_ Nor_gate
X_2366_ net32 VGND VGND VPWR VPWR _1475_ sky130_fd_sc_hd__clkbuf_4
X_2297_ VGND VGND VPWR VPWR _1380_ _1402_ _1391_ Nand_gate
XFILLER_0_2_41 VPWR VGND VPWR VGND sky130_ef_sc_hd__decap_12
XPHY_107 VGND VGND VPWR VPWR sky130_fd_sc_hd__decap_3
XFILLER_0_2_85 VPWR VGND VPWR VGND sky130_ef_sc_hd__decap_12
XFILLER_0_6_150 VGND VGND VPWR VPWR sky130_fd_sc_hd__fill_1
XFILLER_0_6_183 VGND VGND VPWR VPWR sky130_fd_sc_hd__decap_8
XPHY_9 VGND VGND VPWR VPWR sky130_fd_sc_hd__decap_3
XFILLER_0_25_248 VGND VGND VPWR VPWR sky130_fd_sc_hd__decap_4
XFILLER_0_33_281 VGND VGND VPWR VPWR sky130_fd_sc_hd__decap_8
XFILLER_0_25_259 VPWR VGND VPWR VGND sky130_ef_sc_hd__decap_12
X_2220_ VGND VGND VPWR VPWR _0571_ _0560_ inverter
XFILLER_0_48_307 VGND VGND VPWR VPWR sky130_fd_sc_hd__fill_1
X_2984_ VGND VGND VPWR VPWR _2079_ _2086_ _2087_ Nor_gate
XFILLER_0_16_9 VGND VGND VPWR VPWR sky130_fd_sc_hd__decap_8
X_3605_ VGND VGND VPWR VPWR _1862_ _0578_ _0579_ Nor_gate
XFILLER_0_3_131 VGND VGND VPWR VPWR sky130_fd_sc_hd__fill_2
Xinput61 b[31] VGND VGND VPWR VPWR net61 sky130_fd_sc_hd__clkbuf_2
Xinput50 b[21] VGND VGND VPWR VPWR net50 sky130_fd_sc_hd__dlymetal6s2s_1
XFILLER_0_16_237 VGND VGND VPWR VPWR sky130_fd_sc_hd__fill_1
XFILLER_0_58_93 VGND VGND VPWR VPWR sky130_fd_sc_hd__decap_8
X_3536_ VGND VGND VPWR VPWR _0504_ _0500_ _0503_ _1870_ Mux
X_3467_ VGND VGND VPWR VPWR _0290_ _0429_ _0361_ Nand_gate
X_3398_ _1813_ VGND VGND VPWR VPWR _0355_ sky130_fd_sc_hd__clkbuf_4
X_2418_ VGND VGND VPWR VPWR _1527_ net52 inverter
X_4019_ VGND VGND VPWR VPWR _0987_ _1027_ _1026_ Nand_gate
X_2349_ VGND VGND VPWR VPWR net28 net64 _1458_ Nor_gate
XFILLER_0_54_29 VPWR VGND VPWR VGND sky130_ef_sc_hd__decap_12
XTAP_457 VGND VPWR sky130_fd_sc_hd__tapvpwrvgnd_1
X_3252_ VGND VGND VPWR VPWR _0197_ _0047_ _0196_ _1432_ Mux
XTAP_446 VGND VPWR sky130_fd_sc_hd__tapvpwrvgnd_1
XTAP_435 VGND VPWR sky130_fd_sc_hd__tapvpwrvgnd_1
XTAP_424 VGND VPWR sky130_fd_sc_hd__tapvpwrvgnd_1
XTAP_413 VGND VPWR sky130_fd_sc_hd__tapvpwrvgnd_1
XTAP_402 VGND VPWR sky130_fd_sc_hd__tapvpwrvgnd_1
X_4370_ VGND VGND VPWR VPWR _1372_ _1405_ _1404_ Nand_gate
XFILLER_0_21_284 VGND VGND VPWR VPWR sky130_fd_sc_hd__decap_6
XFILLER_0_0_134 VGND VGND VPWR VPWR sky130_fd_sc_hd__fill_2
X_3321_ VGND VGND VPWR VPWR _0267_ _0271_ _0272_ Nor_gate
XTAP_479 VGND VPWR sky130_fd_sc_hd__tapvpwrvgnd_1
X_2203_ net14 VGND VGND VPWR VPWR _0387_ sky130_fd_sc_hd__clkbuf_4
XTAP_468 VGND VPWR sky130_fd_sc_hd__tapvpwrvgnd_1
X_3183_ VGND VGND VPWR VPWR _1475_ _0122_ _0072_ Nand_gate
XFILLER_0_44_321 VPWR VGND VPWR VGND sky130_ef_sc_hd__decap_12
XFILLER_0_29_340 VGND VGND VPWR VPWR sky130_fd_sc_hd__fill_1
X_2967_ VGND VGND VPWR VPWR _2070_ _2069_ inverter
XFILLER_0_8_212 VGND VGND VPWR VPWR sky130_fd_sc_hd__decap_6
XFILLER_0_8_267 VGND VGND VPWR VPWR sky130_fd_sc_hd__fill_2
X_2898_ VGND VGND VPWR VPWR _2000_ _2002_ _2003_ Nor_gate
XFILLER_0_12_273 VGND VGND VPWR VPWR sky130_fd_sc_hd__fill_1
X_3519_ VGND VGND VPWR VPWR _0481_ _0486_ _0485_ Nand_gate
XFILLER_0_39_148 VGND VGND VPWR VPWR sky130_fd_sc_hd__fill_1
XFILLER_0_54_129 VGND VGND VPWR VPWR sky130_fd_sc_hd__fill_1
XFILLER_0_47_181 VPWR VGND VPWR VGND sky130_ef_sc_hd__decap_12
X_2821_ VGND VGND VPWR VPWR _1927_ _1925_ _1926_ _1438_ Mux
XFILLER_0_26_321 VGND VGND VPWR VPWR sky130_fd_sc_hd__decap_4
X_3870_ VGND VGND VPWR VPWR net50 net49 _0865_ Nor_gate
XFILLER_0_14_21 VGND VGND VPWR VPWR sky130_fd_sc_hd__decap_6
XFILLER_0_14_76 VGND VGND VPWR VPWR sky130_fd_sc_hd__fill_2
XFILLER_0_41_313 VGND VGND VPWR VPWR sky130_fd_sc_hd__decap_8
X_2752_ VGND VGND VPWR VPWR _1648_ _1858_ _1859_ Nor_gate
X_2683_ _1790_ VGND VGND VPWR VPWR _1791_ sky130_fd_sc_hd__buf_2
X_3304_ VGND VGND VPWR VPWR _0253_ _2156_ _0252_ _1606_ Mux
X_3235_ VGND VGND VPWR VPWR _0178_ _1854_ inverter
XTAP_298 VGND VPWR sky130_fd_sc_hd__tapvpwrvgnd_1
X_4284_ VGND VGND VPWR VPWR _0519_ _1311_ _1312_ Nor_gate
XTAP_287 VGND VPWR sky130_fd_sc_hd__tapvpwrvgnd_1
XTAP_276 VGND VPWR sky130_fd_sc_hd__tapvpwrvgnd_1
XTAP_265 VGND VPWR sky130_fd_sc_hd__tapvpwrvgnd_1
XTAP_254 VGND VPWR sky130_fd_sc_hd__tapvpwrvgnd_1
XTAP_243 VGND VPWR sky130_fd_sc_hd__tapvpwrvgnd_1
X_4353_ VGND VGND VPWR VPWR net99 _1385_ _1386_ Nor_gate
XTAP_210 VGND VPWR sky130_fd_sc_hd__tapvpwrvgnd_1
XTAP_221 VGND VPWR sky130_fd_sc_hd__tapvpwrvgnd_1
XTAP_232 VGND VPWR sky130_fd_sc_hd__tapvpwrvgnd_1
X_3166_ VGND VGND VPWR VPWR _0102_ _0103_ _1745_ Nand_gate
X_3097_ VGND VGND VPWR VPWR _0021_ _0027_ _0028_ Nor_gate
XFILLER_0_12_3 VPWR VGND VPWR VGND sky130_ef_sc_hd__decap_12
X_3999_ VGND VGND VPWR VPWR _0102_ _1004_ _1005_ Nor_gate
XFILLER_0_44_173 VGND VGND VPWR VPWR sky130_fd_sc_hd__decap_6
XFILLER_0_4_281 VGND VGND VPWR VPWR sky130_fd_sc_hd__fill_2
XFILLER_0_51_19 VPWR VGND VPWR VGND sky130_ef_sc_hd__decap_12
XFILLER_0_58_210 VGND VGND VPWR VPWR sky130_fd_sc_hd__decap_8
XFILLER_0_25_97 VPWR VGND VPWR VGND sky130_ef_sc_hd__decap_12
XFILLER_0_25_75 VGND VGND VPWR VPWR sky130_fd_sc_hd__fill_1
XFILLER_0_25_53 VGND VGND VPWR VPWR sky130_fd_sc_hd__decap_3
X_3020_ VGND VGND VPWR VPWR _1454_ _2122_ _2123_ Nor_gate
X_3853_ VGND VGND VPWR VPWR _0229_ _0846_ _0847_ Nor_gate
XFILLER_0_41_63 VGND VGND VPWR VPWR sky130_fd_sc_hd__fill_1
XFILLER_0_41_30 VPWR VGND VPWR VGND sky130_ef_sc_hd__decap_12
X_2804_ VGND VGND VPWR VPWR _1910_ _1909_ inverter
X_3784_ VGND VGND VPWR VPWR _0655_ _0717_ _0772_ Nor_gate
X_3922_ VGND VGND VPWR VPWR _0868_ _0920_ _0921_ Nor_gate
X_2735_ VGND VGND VPWR VPWR _1842_ net24 net25 net37 Mux
XFILLER_0_41_187 VGND VGND VPWR VPWR sky130_fd_sc_hd__fill_1
XFILLER_0_41_176 VGND VGND VPWR VPWR sky130_fd_sc_hd__fill_1
XFILLER_0_41_110 VGND VGND VPWR VPWR sky130_fd_sc_hd__fill_2
X_2666_ VGND VGND VPWR VPWR _1650_ _1774_ _1773_ Nand_gate
X_2597_ VGND VGND VPWR VPWR _1704_ _1705_ _1706_ Nor_gate
X_4336_ VGND VGND VPWR VPWR _1343_ _1367_ _1368_ Nor_gate
XFILLER_0_1_273 VGND VGND VPWR VPWR sky130_fd_sc_hd__decap_6
X_4198_ VGND VGND VPWR VPWR _1862_ _1218_ _1220_ Nor_gate
X_4267_ VGND VGND VPWR VPWR _1288_ _1293_ _1292_ Nand_gate
X_3218_ VGND VGND VPWR VPWR _0160_ _0015_ inverter
X_3149_ VGND VGND VPWR VPWR _0070_ _0085_ _0086_ Nor_gate
XFILLER_0_49_254 VPWR VGND VPWR VGND sky130_ef_sc_hd__decap_12
XFILLER_0_20_305 VGND VGND VPWR VPWR sky130_fd_sc_hd__decap_3
XFILLER_0_17_151 VPWR VGND VPWR VGND sky130_ef_sc_hd__decap_12
XFILLER_0_17_195 VGND VGND VPWR VPWR sky130_fd_sc_hd__fill_2
XFILLER_0_55_279 VGND VGND VPWR VPWR sky130_fd_sc_hd__fill_1
X_2520_ VGND VGND VPWR VPWR _1629_ _1626_ _1627_ _1628_ Mux
X_2451_ VGND VGND VPWR VPWR _1560_ _0073_ inverter
XFILLER_0_46_9 VPWR VGND VPWR VGND sky130_ef_sc_hd__decap_12
Xinput4 a[12] VGND VGND VPWR VPWR net4 sky130_fd_sc_hd__buf_1
X_3003_ VGND VGND VPWR VPWR _2106_ _1835_ _1853_ _1438_ Mux
X_4121_ VGND VGND VPWR VPWR _1081_ _1136_ _1135_ Nand_gate
X_4052_ VGND VGND VPWR VPWR _0109_ _1062_ _0741_ Nand_gate
X_2382_ net5 VGND VGND VPWR VPWR _1491_ sky130_fd_sc_hd__clkbuf_4
X_3905_ VGND VGND VPWR VPWR _0594_ _0903_ _0902_ Nand_gate
X_2718_ VGND VGND VPWR VPWR _1633_ _1824_ _1825_ Nor_gate
XFILLER_0_6_343 VGND VGND VPWR VPWR sky130_fd_sc_hd__fill_1
X_3836_ VGND VGND VPWR VPWR _0825_ _0827_ _0828_ Nor_gate
X_3767_ VGND VGND VPWR VPWR _0729_ _0754_ _0753_ Nand_gate
XFILLER_0_14_121 VGND VGND VPWR VPWR sky130_fd_sc_hd__decap_4
X_4319_ VGND VGND VPWR VPWR _0686_ _1350_ _0505_ Nand_gate
X_2649_ VGND VGND VPWR VPWR _1757_ _1756_ inverter
X_3698_ VGND VGND VPWR VPWR _0675_ _0678_ _0680_ Nor_gate
XFILLER_0_14_176 VGND VGND VPWR VPWR sky130_fd_sc_hd__decap_8
XFILLER_0_52_216 VGND VGND VPWR VPWR sky130_fd_sc_hd__decap_4
XFILLER_0_37_202 VGND VGND VPWR VPWR sky130_fd_sc_hd__fill_1
XFILLER_0_9_192 VPWR VGND VPWR VGND sky130_ef_sc_hd__decap_12
XFILLER_0_20_113 VGND VGND VPWR VPWR sky130_fd_sc_hd__decap_6
X_3621_ VGND VGND VPWR VPWR _1982_ _0597_ _0596_ Nand_gate
X_3552_ VGND VGND VPWR VPWR _0519_ _0522_ _0521_ Nand_gate
XFILLER_0_22_98 VGND VGND VPWR VPWR sky130_fd_sc_hd__decap_8
XFILLER_0_22_65 VPWR VGND VPWR VGND sky130_ef_sc_hd__decap_12
XFILLER_0_22_54 VGND VGND VPWR VPWR sky130_fd_sc_hd__decap_4
XFILLER_0_51_7 VPWR VGND VPWR VGND sky130_ef_sc_hd__decap_12
X_2503_ VGND VGND VPWR VPWR _1612_ _1609_ _1611_ _1589_ Mux
X_2434_ VGND VGND VPWR VPWR _0322_ _1542_ _1543_ Nor_gate
X_3483_ VGND VGND VPWR VPWR _0443_ _0446_ _0447_ Nor_gate
X_2365_ VGND VGND VPWR VPWR net2 _1473_ _1474_ Nor_gate
X_4104_ VGND VGND VPWR VPWR _0179_ _1117_ _1118_ Nor_gate
X_4035_ VGND VGND VPWR VPWR _0989_ _1042_ _1043_ Nor_gate
X_2296_ VGND VGND VPWR VPWR _1391_ net65 inverter
XFILLER_0_2_53 VPWR VGND VPWR VGND sky130_ef_sc_hd__decap_12
XPHY_108 VGND VGND VPWR VPWR sky130_fd_sc_hd__decap_3
XFILLER_0_2_97 VPWR VGND VPWR VGND sky130_ef_sc_hd__decap_12
XFILLER_0_34_227 VGND VGND VPWR VPWR sky130_fd_sc_hd__fill_2
X_3819_ VGND VGND VPWR VPWR _0511_ _0810_ _0811_ Nor_gate
XFILLER_0_33_293 VPWR VGND VPWR VGND sky130_ef_sc_hd__decap_12
XFILLER_0_17_21 VPWR VGND VPWR VGND sky130_ef_sc_hd__decap_12
XFILLER_0_17_87 VGND VGND VPWR VPWR sky130_fd_sc_hd__decap_4
XFILLER_0_56_341 VGND VGND VPWR VPWR sky130_fd_sc_hd__fill_2
X_2983_ VGND VGND VPWR VPWR _2084_ _2085_ _2086_ Nor_gate
X_3535_ VGND VGND VPWR VPWR _0503_ _0502_ inverter
X_3604_ VGND VGND VPWR VPWR _0578_ _0050_ _0577_ _1726_ Mux
Xinput51 b[22] VGND VGND VPWR VPWR net51 sky130_fd_sc_hd__buf_2
XFILLER_0_3_165 VGND VGND VPWR VPWR sky130_fd_sc_hd__decap_3
Xinput40 b[12] VGND VGND VPWR VPWR net40 sky130_fd_sc_hd__buf_2
Xinput62 b[3] VGND VGND VPWR VPWR net62 sky130_fd_sc_hd__buf_2
XFILLER_0_58_83 VGND VGND VPWR VPWR sky130_fd_sc_hd__fill_1
XFILLER_0_42_3 VPWR VGND VPWR VGND sky130_ef_sc_hd__decap_12
X_2348_ VGND VGND VPWR VPWR _1410_ _1412_ _1457_ Nor_gate
X_3397_ _0353_ VGND VGND VPWR VPWR net72 sky130_fd_sc_hd__buf_1
XFILLER_0_3_198 VGND VGND VPWR VPWR sky130_fd_sc_hd__decap_8
X_3466_ VGND VGND VPWR VPWR _0428_ _0307_ inverter
X_2417_ VGND VGND VPWR VPWR _0560_ _1525_ _1526_ Nor_gate
X_4018_ VGND VGND VPWR VPWR _0994_ _1024_ _1026_ Nor_gate
X_2279_ VGND VGND VPWR VPWR _1208_ _1197_ inverter
XFILLER_0_30_230 VGND VGND VPWR VPWR sky130_fd_sc_hd__decap_8
XTAP_469 VGND VPWR sky130_fd_sc_hd__tapvpwrvgnd_1
XTAP_458 VGND VPWR sky130_fd_sc_hd__tapvpwrvgnd_1
X_3251_ VGND VGND VPWR VPWR _0196_ net2 _1475_ _1607_ Mux
XTAP_447 VGND VPWR sky130_fd_sc_hd__tapvpwrvgnd_1
XTAP_436 VGND VPWR sky130_fd_sc_hd__tapvpwrvgnd_1
XTAP_425 VGND VPWR sky130_fd_sc_hd__tapvpwrvgnd_1
XTAP_414 VGND VPWR sky130_fd_sc_hd__tapvpwrvgnd_1
XTAP_403 VGND VPWR sky130_fd_sc_hd__tapvpwrvgnd_1
XFILLER_0_28_64 VGND VGND VPWR VPWR sky130_fd_sc_hd__decap_6
XFILLER_0_0_113 VGND VGND VPWR VPWR sky130_fd_sc_hd__decap_8
X_3182_ VGND VGND VPWR VPWR _1475_ _0072_ _0121_ Nor_gate
X_3320_ VGND VGND VPWR VPWR _0269_ _0271_ _0270_ Nand_gate
X_2202_ VGND VGND VPWR VPWR _0344_ _0365_ _0376_ Nor_gate
XFILLER_0_44_41 VGND VGND VPWR VPWR sky130_fd_sc_hd__decap_4
XFILLER_0_48_138 VGND VGND VPWR VPWR sky130_fd_sc_hd__fill_2
XFILLER_0_44_333 VPWR VGND VPWR VGND sky130_ef_sc_hd__decap_12
X_2966_ VGND VGND VPWR VPWR net63 net64 _2069_ Nor_gate
X_2897_ _2001_ VGND VGND VPWR VPWR _2002_ sky130_fd_sc_hd__buf_2
XFILLER_0_8_246 VGND VGND VPWR VPWR sky130_fd_sc_hd__fill_2
X_3518_ VGND VGND VPWR VPWR _0482_ _0485_ _0483_ Nand_gate
XFILLER_0_8_41 VPWR VGND VPWR VGND sky130_ef_sc_hd__decap_12
X_3449_ VGND VGND VPWR VPWR _0392_ _0411_ _0410_ Nand_gate
XFILLER_0_47_193 VPWR VGND VPWR VGND sky130_ef_sc_hd__decap_12
X_2820_ VGND VGND VPWR VPWR _1926_ _1715_ _1727_ _1716_ Mux
X_2751_ VGND VGND VPWR VPWR _1852_ _1857_ _1858_ Nor_gate
XFILLER_0_5_216 VGND VGND VPWR VPWR sky130_fd_sc_hd__fill_1
XFILLER_0_14_88 VGND VGND VPWR VPWR sky130_fd_sc_hd__fill_2
XFILLER_0_53_163 VGND VGND VPWR VPWR sky130_fd_sc_hd__fill_2
X_2682_ VGND VGND VPWR VPWR _1642_ _1790_ _1789_ Nand_gate
X_4352_ VGND VGND VPWR VPWR _1385_ _1384_ inverter
X_3303_ VGND VGND VPWR VPWR _0252_ _0136_ _0251_ _2155_ Mux
X_3165_ _1671_ VGND VGND VPWR VPWR _0102_ sky130_fd_sc_hd__clkbuf_4
X_3234_ VGND VGND VPWR VPWR _0174_ _0176_ _0177_ Nor_gate
XTAP_299 VGND VPWR sky130_fd_sc_hd__tapvpwrvgnd_1
X_4283_ VGND VGND VPWR VPWR _0686_ _0466_ _1311_ Nor_gate
XTAP_288 VGND VPWR sky130_fd_sc_hd__tapvpwrvgnd_1
XTAP_277 VGND VPWR sky130_fd_sc_hd__tapvpwrvgnd_1
XTAP_266 VGND VPWR sky130_fd_sc_hd__tapvpwrvgnd_1
XTAP_255 VGND VPWR sky130_fd_sc_hd__tapvpwrvgnd_1
XTAP_244 VGND VPWR sky130_fd_sc_hd__tapvpwrvgnd_1
XTAP_233 VGND VPWR sky130_fd_sc_hd__tapvpwrvgnd_1
XTAP_200 VGND VPWR sky130_fd_sc_hd__tapvpwrvgnd_1
XTAP_211 VGND VPWR sky130_fd_sc_hd__tapvpwrvgnd_1
XTAP_222 VGND VPWR sky130_fd_sc_hd__tapvpwrvgnd_1
X_3096_ VGND VGND VPWR VPWR _0027_ _0026_ inverter
X_3998_ VGND VGND VPWR VPWR _1004_ _1002_ inverter
XFILLER_0_44_163 VGND VGND VPWR VPWR sky130_fd_sc_hd__fill_1
XFILLER_0_44_141 VGND VGND VPWR VPWR sky130_fd_sc_hd__decap_6
X_2949_ VGND VGND VPWR VPWR _1649_ _2053_ _2052_ Nand_gate
XFILLER_0_29_193 VGND VGND VPWR VPWR sky130_fd_sc_hd__fill_2
XFILLER_0_17_333 VGND VGND VPWR VPWR sky130_fd_sc_hd__decap_3
XFILLER_0_35_130 VGND VGND VPWR VPWR sky130_fd_sc_hd__decap_8
XFILLER_0_27_108 VGND VGND VPWR VPWR sky130_fd_sc_hd__fill_1
XFILLER_0_50_188 VGND VGND VPWR VPWR sky130_fd_sc_hd__decap_8
XFILLER_0_58_233 VGND VGND VPWR VPWR sky130_fd_sc_hd__fill_1
X_3921_ VGND VGND VPWR VPWR _1529_ _0355_ _0920_ Nor_gate
X_3852_ VGND VGND VPWR VPWR _0846_ _0627_ _0845_ _0379_ Mux
X_2734_ VGND VGND VPWR VPWR _1841_ _1839_ _1840_ _1628_ Mux
XFILLER_0_41_122 VGND VGND VPWR VPWR sky130_fd_sc_hd__decap_3
XFILLER_0_41_97 VGND VGND VPWR VPWR sky130_fd_sc_hd__fill_1
XFILLER_0_41_42 VGND VGND VPWR VPWR sky130_fd_sc_hd__decap_8
X_2803_ VGND VGND VPWR VPWR _1419_ _1908_ _1909_ Nor_gate
XFILLER_0_26_174 VGND VGND VPWR VPWR sky130_fd_sc_hd__fill_1
XFILLER_0_26_141 VGND VGND VPWR VPWR sky130_fd_sc_hd__fill_1
X_3783_ VGND VGND VPWR VPWR _0768_ _0771_ _0770_ Nand_gate
X_2665_ VGND VGND VPWR VPWR _1747_ _1773_ _1772_ Nand_gate
X_4335_ VGND VGND VPWR VPWR _1367_ _1366_ inverter
X_2596_ VGND VGND VPWR VPWR _1701_ _1692_ _1705_ Nor_gate
X_4197_ VGND VGND VPWR VPWR _0228_ _1217_ _1218_ Nor_gate
X_4266_ VGND VGND VPWR VPWR _1244_ _1291_ _1292_ Nor_gate
XFILLER_0_5_75 VPWR VGND VPWR VGND sky130_ef_sc_hd__decap_12
X_3217_ VGND VGND VPWR VPWR _0095_ _0157_ _0158_ Nor_gate
X_3148_ VGND VGND VPWR VPWR _0075_ _0085_ _0083_ Nand_gate
XFILLER_0_49_299 VPWR VGND VPWR VGND sky130_ef_sc_hd__decap_12
XFILLER_0_49_266 VGND VGND VPWR VPWR sky130_fd_sc_hd__decap_4
XFILLER_0_49_222 VGND VGND VPWR VPWR sky130_fd_sc_hd__fill_2
X_3079_ VGND VGND VPWR VPWR _0011_ _0010_ inverter
XFILLER_0_17_130 VGND VGND VPWR VPWR sky130_fd_sc_hd__fill_2
XFILLER_0_32_177 VGND VGND VPWR VPWR sky130_fd_sc_hd__fill_1
XFILLER_0_32_144 VGND VGND VPWR VPWR sky130_fd_sc_hd__decap_8
XFILLER_0_20_339 VGND VGND VPWR VPWR sky130_fd_sc_hd__decap_8
XFILLER_0_17_163 VGND VGND VPWR VPWR sky130_fd_sc_hd__fill_2
XFILLER_0_55_225 VPWR VGND VPWR VGND sky130_ef_sc_hd__decap_12
XFILLER_0_55_203 VPWR VGND VPWR VGND sky130_ef_sc_hd__decap_12
X_2450_ VGND VGND VPWR VPWR net25 _0051_ _1559_ Nor_gate
X_2381_ VGND VGND VPWR VPWR _0852_ _1489_ _1490_ Nor_gate
Xinput5 a[13] VGND VGND VPWR VPWR net5 sky130_fd_sc_hd__clkbuf_2
X_4051_ VGND VGND VPWR VPWR _1050_ _1060_ _1061_ Nor_gate
XFILLER_0_36_97 VGND VGND VPWR VPWR sky130_fd_sc_hd__fill_2
X_4120_ VGND VGND VPWR VPWR net55 _1135_ _0215_ Nand_gate
X_3002_ VGND VGND VPWR VPWR _1982_ _2104_ _2105_ Nor_gate
XFILLER_0_52_85 VGND VGND VPWR VPWR sky130_fd_sc_hd__decap_8
X_3904_ VGND VGND VPWR VPWR _0229_ _0902_ _0453_ Nand_gate
X_2717_ VGND VGND VPWR VPWR _1824_ _1823_ _1617_ _1432_ Mux
X_3766_ VGND VGND VPWR VPWR _0732_ _0752_ _0753_ Nor_gate
X_3697_ VGND VGND VPWR VPWR _0676_ _0678_ _0677_ Nand_gate
X_3835_ VGND VGND VPWR VPWR _0826_ _0827_ _0786_ Nand_gate
X_4318_ VGND VGND VPWR VPWR _0686_ _1347_ _1349_ Nor_gate
X_2648_ VGND VGND VPWR VPWR _1756_ _1750_ _1755_ _1633_ Mux
X_2579_ VGND VGND VPWR VPWR _1676_ _1688_ _1687_ Nand_gate
X_4249_ VGND VGND VPWR VPWR _1568_ _1274_ _1275_ Nor_gate
XFILLER_0_52_239 VPWR VGND VPWR VGND sky130_ef_sc_hd__decap_12
XFILLER_0_37_225 VGND VGND VPWR VPWR sky130_fd_sc_hd__fill_2
XFILLER_0_9_182 VGND VGND VPWR VPWR sky130_fd_sc_hd__fill_1
XFILLER_0_20_103 VGND VGND VPWR VPWR sky130_fd_sc_hd__decap_6
XFILLER_0_28_236 VGND VGND VPWR VPWR sky130_fd_sc_hd__decap_6
XFILLER_0_51_250 VPWR VGND VPWR VGND sky130_ef_sc_hd__decap_12
X_2502_ VGND VGND VPWR VPWR _1611_ net29 _1316_ _1610_ Mux
XFILLER_0_43_217 VGND VGND VPWR VPWR sky130_fd_sc_hd__decap_6
X_3620_ VGND VGND VPWR VPWR _0592_ _0596_ _0595_ Nand_gate
X_3551_ VGND VGND VPWR VPWR _0113_ _0521_ _0520_ Nand_gate
XFILLER_0_22_77 VGND VGND VPWR VPWR sky130_fd_sc_hd__decap_4
XFILLER_0_44_7 VPWR VGND VPWR VGND sky130_ef_sc_hd__decap_12
X_4103_ VGND VGND VPWR VPWR _0738_ _1117_ _1922_ Nand_gate
X_3482_ VGND VGND VPWR VPWR _0863_ _0445_ _0446_ Nor_gate
X_2433_ VGND VGND VPWR VPWR _1526_ _1541_ _1542_ Nor_gate
X_2364_ VGND VGND VPWR VPWR _1473_ net38 inverter
XFILLER_0_47_74 VGND VGND VPWR VPWR sky130_fd_sc_hd__fill_1
X_4034_ VGND VGND VPWR VPWR net17 _1042_ net18 Nand_gate
X_2295_ VGND VGND VPWR VPWR _1380_ net29 inverter
XFILLER_0_2_65 VPWR VGND VPWR VGND sky130_ef_sc_hd__decap_12
XPHY_109 VGND VGND VPWR VPWR sky130_fd_sc_hd__decap_3
XFILLER_0_19_258 VGND VGND VPWR VPWR sky130_fd_sc_hd__fill_1
XFILLER_0_19_225 VGND VGND VPWR VPWR sky130_fd_sc_hd__decap_4
XFILLER_0_19_214 VGND VGND VPWR VPWR sky130_fd_sc_hd__decap_3
XFILLER_0_19_203 VGND VGND VPWR VPWR sky130_fd_sc_hd__decap_4
X_3818_ VGND VGND VPWR VPWR _0810_ _0512_ _0513_ _0474_ Mux
X_3749_ VGND VGND VPWR VPWR _0735_ _0626_ _0734_ _0255_ Mux
XFILLER_0_42_250 VGND VGND VPWR VPWR sky130_fd_sc_hd__fill_2
XFILLER_0_40_209 VPWR VGND VPWR VGND sky130_ef_sc_hd__decap_12
XFILLER_0_25_228 VGND VGND VPWR VPWR sky130_fd_sc_hd__fill_2
XFILLER_0_0_317 VGND VGND VPWR VPWR sky130_fd_sc_hd__fill_1
XFILLER_0_48_309 VPWR VGND VPWR VGND sky130_ef_sc_hd__decap_12
XFILLER_0_17_33 VPWR VGND VPWR VGND sky130_ef_sc_hd__decap_12
XFILLER_0_17_55 VGND VGND VPWR VPWR sky130_fd_sc_hd__fill_1
XFILLER_0_33_65 VGND VGND VPWR VPWR sky130_fd_sc_hd__decap_8
XFILLER_0_33_54 VGND VGND VPWR VPWR sky130_fd_sc_hd__fill_2
X_2982_ VGND VGND VPWR VPWR _1972_ _2085_ _2026_ Nand_gate
XFILLER_0_16_206 VGND VGND VPWR VPWR sky130_fd_sc_hd__decap_4
X_3534_ VGND VGND VPWR VPWR _0502_ _0403_ _0501_ _2155_ Mux
X_3603_ VGND VGND VPWR VPWR _0577_ _0331_ _0576_ _1605_ Mux
Xinput41 b[13] VGND VGND VPWR VPWR net41 sky130_fd_sc_hd__buf_2
XFILLER_0_24_250 VGND VGND VPWR VPWR sky130_fd_sc_hd__fill_2
XFILLER_0_3_177 VPWR VGND VPWR VGND sky130_ef_sc_hd__decap_12
XFILLER_0_3_111 VGND VGND VPWR VPWR sky130_fd_sc_hd__fill_1
Xinput63 b[4] VGND VGND VPWR VPWR net63 sky130_fd_sc_hd__clkbuf_4
Xinput52 b[23] VGND VGND VPWR VPWR net52 sky130_fd_sc_hd__buf_2
Xinput30 a[7] VGND VGND VPWR VPWR net30 sky130_fd_sc_hd__dlymetal6s2s_1
X_3465_ VGND VGND VPWR VPWR _0423_ _0426_ _0427_ Nor_gate
XFILLER_0_58_51 VGND VGND VPWR VPWR sky130_fd_sc_hd__decap_4
XFILLER_0_35_3 VGND VGND VPWR VPWR sky130_fd_sc_hd__decap_6
X_2347_ VGND VGND VPWR VPWR _1454_ _1455_ _1456_ Nor_gate
X_3396_ VGND VGND VPWR VPWR _0312_ _0353_ _0352_ Nand_gate
X_2416_ VGND VGND VPWR VPWR _1506_ _1524_ _1525_ Nor_gate
X_2278_ VGND VGND VPWR VPWR net2 _1197_ net38 Nand_gate
X_4017_ VGND VGND VPWR VPWR _1008_ _1024_ _1023_ Nand_gate
XFILLER_0_30_286 VGND VGND VPWR VPWR sky130_fd_sc_hd__fill_2
XFILLER_0_53_345 VGND VGND VPWR VPWR sky130_fd_sc_hd__fill_2
XFILLER_0_53_334 VGND VGND VPWR VPWR sky130_fd_sc_hd__fill_2
XFILLER_0_21_253 VPWR VGND VPWR VGND sky130_ef_sc_hd__decap_12
XFILLER_0_21_231 VGND VGND VPWR VPWR sky130_fd_sc_hd__decap_8
XFILLER_0_0_103 VGND VGND VPWR VPWR sky130_fd_sc_hd__decap_3
XTAP_459 VGND VPWR sky130_fd_sc_hd__tapvpwrvgnd_1
XTAP_448 VGND VPWR sky130_fd_sc_hd__tapvpwrvgnd_1
XTAP_437 VGND VPWR sky130_fd_sc_hd__tapvpwrvgnd_1
XTAP_426 VGND VPWR sky130_fd_sc_hd__tapvpwrvgnd_1
XTAP_415 VGND VPWR sky130_fd_sc_hd__tapvpwrvgnd_1
XTAP_404 VGND VPWR sky130_fd_sc_hd__tapvpwrvgnd_1
X_3181_ VGND VGND VPWR VPWR _0113_ _0119_ _0120_ Nor_gate
XFILLER_0_0_169 VGND VGND VPWR VPWR sky130_fd_sc_hd__decap_8
X_2201_ VGND VGND VPWR VPWR _0365_ _0354_ inverter
X_3250_ VGND VGND VPWR VPWR _0191_ _0194_ _0195_ Nor_gate
XFILLER_0_44_345 VGND VGND VPWR VPWR sky130_fd_sc_hd__fill_2
X_2965_ _2068_ VGND VGND VPWR VPWR net96 sky130_fd_sc_hd__buf_1
X_2896_ VGND VGND VPWR VPWR _1599_ _1920_ _2001_ Nor_gate
X_3448_ VGND VGND VPWR VPWR _0400_ _0408_ _0410_ Nor_gate
X_3517_ VGND VGND VPWR VPWR _0483_ _0434_ inverter
XFILLER_0_12_253 VPWR VGND VPWR VGND sky130_ef_sc_hd__decap_12
XFILLER_0_12_286 VGND VGND VPWR VPWR sky130_fd_sc_hd__decap_8
X_3379_ VGND VGND VPWR VPWR _1703_ _0334_ _0335_ Nor_gate
XFILLER_0_35_334 VGND VGND VPWR VPWR sky130_fd_sc_hd__fill_2
XFILLER_0_7_291 VPWR VGND VPWR VGND sky130_ef_sc_hd__decap_12
XFILLER_0_14_45 VPWR VGND VPWR VGND sky130_ef_sc_hd__decap_12
XFILLER_0_38_194 VGND VGND VPWR VPWR sky130_fd_sc_hd__fill_2
XFILLER_0_38_172 VGND VGND VPWR VPWR sky130_fd_sc_hd__decap_8
X_2750_ VGND VGND VPWR VPWR _1700_ _1856_ _1857_ Nor_gate
XFILLER_0_26_345 VGND VGND VPWR VPWR sky130_fd_sc_hd__fill_2
X_2681_ VGND VGND VPWR VPWR _1678_ net33 _1789_ Nor_gate
X_3302_ VGND VGND VPWR VPWR _0251_ _1230_ net2 _1667_ Mux
XFILLER_0_41_337 VGND VGND VPWR VPWR sky130_fd_sc_hd__decap_8
XFILLER_0_41_326 VGND VGND VPWR VPWR sky130_fd_sc_hd__decap_8
X_4351_ VGND VGND VPWR VPWR net96 net97 _1384_ Nor_gate
X_4282_ VGND VGND VPWR VPWR _1310_ _1309_ inverter
XTAP_201 VGND VPWR sky130_fd_sc_hd__tapvpwrvgnd_1
XTAP_212 VGND VPWR sky130_fd_sc_hd__tapvpwrvgnd_1
XTAP_223 VGND VPWR sky130_fd_sc_hd__tapvpwrvgnd_1
XFILLER_0_39_97 VPWR VGND VPWR VGND sky130_ef_sc_hd__decap_12
X_3233_ VGND VGND VPWR VPWR _1700_ _0176_ _0175_ Nand_gate
XTAP_289 VGND VPWR sky130_fd_sc_hd__tapvpwrvgnd_1
XTAP_278 VGND VPWR sky130_fd_sc_hd__tapvpwrvgnd_1
XTAP_267 VGND VPWR sky130_fd_sc_hd__tapvpwrvgnd_1
XTAP_256 VGND VPWR sky130_fd_sc_hd__tapvpwrvgnd_1
XTAP_245 VGND VPWR sky130_fd_sc_hd__tapvpwrvgnd_1
X_3095_ VGND VGND VPWR VPWR _0022_ _0026_ _0025_ Nand_gate
XTAP_234 VGND VPWR sky130_fd_sc_hd__tapvpwrvgnd_1
X_3164_ VGND VGND VPWR VPWR _0098_ _0100_ _0101_ Nor_gate
X_3997_ VGND VGND VPWR VPWR _1002_ _0797_ _1001_ _1870_ Mux
XFILLER_0_29_150 VGND VGND VPWR VPWR sky130_fd_sc_hd__fill_1
X_2948_ VGND VGND VPWR VPWR _2052_ _2050_ _2051_ _1419_ Mux
XFILLER_0_32_337 VGND VGND VPWR VPWR sky130_fd_sc_hd__fill_1
XFILLER_0_32_315 VGND VGND VPWR VPWR sky130_fd_sc_hd__decap_3
X_2879_ _1693_ VGND VGND VPWR VPWR _1984_ sky130_fd_sc_hd__clkbuf_4
XFILLER_0_17_345 VGND VGND VPWR VPWR sky130_fd_sc_hd__fill_2
XFILLER_0_50_145 VGND VGND VPWR VPWR sky130_fd_sc_hd__fill_1
XFILLER_0_23_337 VGND VGND VPWR VPWR sky130_fd_sc_hd__decap_4
XFILLER_0_2_209 VGND VGND VPWR VPWR sky130_fd_sc_hd__decap_8
XFILLER_0_58_289 VGND VGND VPWR VPWR sky130_fd_sc_hd__fill_2
XFILLER_0_58_278 VGND VGND VPWR VPWR sky130_fd_sc_hd__fill_2
X_3920_ VGND VGND VPWR VPWR net83 _0919_ inverter
X_3851_ VGND VGND VPWR VPWR _0845_ _0734_ _0844_ _2155_ Mux
XFILLER_0_25_33 VPWR VGND VPWR VGND sky130_ef_sc_hd__decap_12
X_2733_ VGND VGND VPWR VPWR _1840_ net21 _1565_ _1667_ Mux
X_2802_ VGND VGND VPWR VPWR _1908_ _1906_ _1907_ _1438_ Mux
XFILLER_0_41_76 VGND VGND VPWR VPWR sky130_fd_sc_hd__decap_3
X_2664_ VGND VGND VPWR VPWR _1671_ _1772_ _1771_ Nand_gate
X_3782_ VGND VGND VPWR VPWR _0558_ _0770_ _0769_ Nand_gate
X_2595_ VGND VGND VPWR VPWR _1699_ _1703_ _1704_ Nor_gate
X_4334_ VGND VGND VPWR VPWR _1352_ _1365_ _1366_ Nor_gate
X_4265_ VGND VGND VPWR VPWR _1203_ _1290_ _1291_ Nor_gate
XFILLER_0_5_87 VGND VGND VPWR VPWR sky130_fd_sc_hd__decap_4
X_4196_ VGND VGND VPWR VPWR _1217_ _0799_ _1216_ _0135_ Mux
X_3216_ VGND VGND VPWR VPWR _0037_ _0093_ _0157_ Nor_gate
X_3147_ VGND VGND VPWR VPWR _0077_ _0082_ _0083_ Nor_gate
X_3078_ VGND VGND VPWR VPWR _2166_ _0009_ _0010_ Nor_gate
XFILLER_0_32_167 VGND VGND VPWR VPWR sky130_fd_sc_hd__fill_1
XFILLER_0_32_112 VGND VGND VPWR VPWR sky130_fd_sc_hd__fill_1
XFILLER_0_55_215 VGND VGND VPWR VPWR sky130_fd_sc_hd__decap_8
XFILLER_0_55_259 VGND VGND VPWR VPWR sky130_fd_sc_hd__decap_3
XFILLER_0_55_237 VPWR VGND VPWR VGND sky130_ef_sc_hd__decap_12
XFILLER_0_23_145 VGND VGND VPWR VPWR sky130_fd_sc_hd__fill_1
X_2380_ VGND VGND VPWR VPWR _1489_ net42 inverter
XFILLER_0_11_318 VGND VGND VPWR VPWR sky130_fd_sc_hd__fill_2
X_4050_ VGND VGND VPWR VPWR _0594_ _1060_ _1059_ Nand_gate
Xinput6 a[14] VGND VGND VPWR VPWR net6 sky130_fd_sc_hd__buf_1
XFILLER_0_36_43 VGND VGND VPWR VPWR sky130_fd_sc_hd__fill_2
X_3001_ VGND VGND VPWR VPWR _2096_ _2103_ _2104_ Nor_gate
X_3903_ VGND VGND VPWR VPWR _0229_ _0900_ _0901_ Nor_gate
X_3834_ VGND VGND VPWR VPWR _0452_ _0826_ _0764_ Nand_gate
XFILLER_0_54_281 VGND VGND VPWR VPWR sky130_fd_sc_hd__decap_8
X_2647_ VGND VGND VPWR VPWR _1752_ _1754_ _1755_ Nor_gate
X_2716_ VGND VGND VPWR VPWR _1823_ _1461_ _1411_ _1607_ Mux
X_3765_ VGND VGND VPWR VPWR _0740_ _0752_ _0751_ Nand_gate
X_3696_ VGND VGND VPWR VPWR _0655_ _0677_ _0674_ Nand_gate
X_4317_ VGND VGND VPWR VPWR _1347_ _0942_ _1346_ _0135_ Mux
X_2578_ VGND VGND VPWR VPWR _1677_ _1687_ _1686_ Nand_gate
X_4248_ VGND VGND VPWR VPWR _0511_ _1272_ _1274_ Nor_gate
X_4179_ VPWR VGND VGND VPWR net57 _1199_ _1198_ Xnor
XFILLER_0_37_259 VGND VGND VPWR VPWR sky130_fd_sc_hd__decap_8
XPHY_90 VGND VGND VPWR VPWR sky130_fd_sc_hd__decap_3
XFILLER_0_43_207 VGND VGND VPWR VPWR sky130_fd_sc_hd__fill_1
XFILLER_0_51_295 VGND VGND VPWR VPWR sky130_fd_sc_hd__fill_2
XFILLER_0_51_262 VPWR VGND VPWR VGND sky130_ef_sc_hd__decap_12
X_2501_ net37 VGND VGND VPWR VPWR _1610_ sky130_fd_sc_hd__clkbuf_4
X_3550_ VGND VGND VPWR VPWR _1922_ _0520_ _1966_ Nand_gate
XFILLER_0_3_337 VGND VGND VPWR VPWR sky130_fd_sc_hd__decap_4
XFILLER_0_11_148 VGND VGND VPWR VPWR sky130_fd_sc_hd__fill_2
X_3481_ VGND VGND VPWR VPWR _1682_ _0444_ _0445_ Nor_gate
XFILLER_0_47_53 VGND VGND VPWR VPWR sky130_fd_sc_hd__decap_3
X_4102_ VGND VGND VPWR VPWR _1766_ _1116_ _1115_ Nand_gate
X_4033_ VGND VGND VPWR VPWR net18 _0990_ _1041_ Nor_gate
X_2294_ VGND VGND VPWR VPWR _1327_ _1370_ _1359_ Nand_gate
X_2363_ VGND VGND VPWR VPWR _1230_ _1471_ _1472_ Nor_gate
X_2432_ VGND VGND VPWR VPWR _1541_ _1540_ inverter
XFILLER_0_2_77 VGND VGND VPWR VPWR sky130_fd_sc_hd__decap_6
X_3748_ VGND VGND VPWR VPWR _0734_ _0582_ _0679_ _1608_ Mux
XFILLER_0_19_248 VGND VGND VPWR VPWR sky130_fd_sc_hd__fill_1
XFILLER_0_6_120 VPWR VGND VPWR VGND sky130_ef_sc_hd__decap_12
X_3817_ VGND VGND VPWR VPWR net49 _0808_ _0393_ Nand_gate
X_3679_ VGND VGND VPWR VPWR _0294_ _0540_ _0659_ Nor_gate
XFILLER_0_25_207 VGND VGND VPWR VPWR sky130_fd_sc_hd__decap_3
XFILLER_0_0_307 VGND VGND VPWR VPWR sky130_fd_sc_hd__fill_1
XFILLER_0_0_329 VGND VGND VPWR VPWR sky130_fd_sc_hd__decap_3
XFILLER_0_33_33 VGND VGND VPWR VPWR sky130_fd_sc_hd__fill_1
XFILLER_0_17_45 VGND VGND VPWR VPWR sky130_fd_sc_hd__decap_6
XFILLER_0_56_321 VPWR VGND VPWR VGND sky130_ef_sc_hd__decap_12
X_3602_ VGND VGND VPWR VPWR _0576_ _0575_ inverter
Xinput20 a[27] VGND VGND VPWR VPWR net20 sky130_fd_sc_hd__clkbuf_4
X_2981_ VGND VGND VPWR VPWR _2083_ _1963_ _2084_ Nor_gate
Xinput31 a[8] VGND VGND VPWR VPWR net31 sky130_fd_sc_hd__clkbuf_4
XFILLER_0_16_229 VGND VGND VPWR VPWR sky130_fd_sc_hd__decap_8
XFILLER_0_58_41 VGND VGND VPWR VPWR sky130_fd_sc_hd__decap_4
X_3533_ VGND VGND VPWR VPWR _0501_ _1014_ _0852_ _1667_ Mux
Xinput64 b[5] VGND VGND VPWR VPWR net64 sky130_fd_sc_hd__clkbuf_2
Xinput42 b[14] VGND VGND VPWR VPWR net42 sky130_fd_sc_hd__clkbuf_2
XFILLER_0_3_189 VGND VGND VPWR VPWR sky130_fd_sc_hd__decap_6
XFILLER_0_3_123 VGND VGND VPWR VPWR sky130_fd_sc_hd__fill_2
Xinput53 b[24] VGND VGND VPWR VPWR net53 sky130_fd_sc_hd__buf_2
X_3464_ VGND VGND VPWR VPWR _0287_ _0425_ _0426_ Nor_gate
X_2415_ VGND VGND VPWR VPWR _1509_ _1523_ _1524_ Nor_gate
XFILLER_0_58_85 VGND VGND VPWR VPWR sky130_fd_sc_hd__fill_2
X_4016_ VGND VGND VPWR VPWR _1011_ _1022_ _1023_ Nor_gate
XFILLER_0_28_3 VGND VGND VPWR VPWR sky130_fd_sc_hd__decap_4
X_2346_ VGND VGND VPWR VPWR _1455_ _1407_ inverter
X_3395_ VGND VGND VPWR VPWR _0337_ _0351_ _0352_ Nor_gate
X_2277_ VGND VGND VPWR VPWR net2 net38 _1186_ Nor_gate
XFILLER_0_30_276 VGND VGND VPWR VPWR sky130_fd_sc_hd__decap_3
XFILLER_0_53_302 VPWR VGND VPWR VGND sky130_ef_sc_hd__decap_12
XFILLER_0_38_321 VGND VGND VPWR VPWR sky130_fd_sc_hd__decap_8
XTAP_405 VGND VPWR sky130_fd_sc_hd__tapvpwrvgnd_1
XFILLER_0_21_265 VGND VGND VPWR VPWR sky130_fd_sc_hd__fill_1
XFILLER_0_0_126 VGND VGND VPWR VPWR sky130_fd_sc_hd__decap_8
XTAP_449 VGND VPWR sky130_fd_sc_hd__tapvpwrvgnd_1
XTAP_438 VGND VPWR sky130_fd_sc_hd__tapvpwrvgnd_1
XTAP_427 VGND VPWR sky130_fd_sc_hd__tapvpwrvgnd_1
XTAP_416 VGND VPWR sky130_fd_sc_hd__tapvpwrvgnd_1
XFILLER_0_28_99 VPWR VGND VPWR VGND sky130_ef_sc_hd__decap_12
XFILLER_0_28_77 VGND VGND VPWR VPWR sky130_fd_sc_hd__fill_1
XFILLER_0_28_22 VGND VGND VPWR VPWR sky130_fd_sc_hd__fill_1
X_3180_ VGND VGND VPWR VPWR _0119_ _0118_ inverter
X_2200_ VGND VGND VPWR VPWR _0333_ _0354_ net51 Nand_gate
XFILLER_0_48_118 VGND VGND VPWR VPWR sky130_fd_sc_hd__decap_3
XFILLER_0_48_107 VGND VGND VPWR VPWR sky130_fd_sc_hd__decap_4
XFILLER_0_44_54 VGND VGND VPWR VPWR sky130_fd_sc_hd__decap_6
X_2964_ VGND VGND VPWR VPWR _2031_ _2068_ _2067_ Nand_gate
XFILLER_0_14_9 VPWR VGND VPWR VGND sky130_ef_sc_hd__decap_12
XFILLER_0_56_195 VGND VGND VPWR VPWR sky130_fd_sc_hd__fill_1
X_2895_ _1700_ VGND VGND VPWR VPWR _2000_ sky130_fd_sc_hd__clkbuf_4
X_3378_ VGND VGND VPWR VPWR _0334_ _2016_ _0332_ _1726_ Mux
X_3447_ VGND VGND VPWR VPWR _1703_ _0407_ _0408_ Nor_gate
X_3516_ VGND VGND VPWR VPWR _0852_ _0482_ _0420_ Nand_gate
XFILLER_0_8_76 VGND VGND VPWR VPWR sky130_fd_sc_hd__decap_8
XFILLER_0_12_265 VGND VGND VPWR VPWR sky130_fd_sc_hd__fill_2
X_2329_ net59 VGND VGND VPWR VPWR _1438_ sky130_fd_sc_hd__clkbuf_4
XFILLER_0_47_140 VPWR VGND VPWR VGND sky130_ef_sc_hd__decap_12
XFILLER_0_7_270 VGND VGND VPWR VPWR sky130_fd_sc_hd__fill_2
XFILLER_0_53_110 VGND VGND VPWR VPWR sky130_fd_sc_hd__fill_2
XFILLER_0_41_305 VGND VGND VPWR VPWR sky130_fd_sc_hd__decap_4
X_2680_ VGND VGND VPWR VPWR _1785_ _1787_ _1788_ Nor_gate
XFILLER_0_26_335 VGND VGND VPWR VPWR sky130_fd_sc_hd__fill_1
XFILLER_0_5_229 VGND VGND VPWR VPWR sky130_fd_sc_hd__fill_1
X_4281_ VGND VGND VPWR VPWR _1302_ _1308_ _1309_ Nor_gate
XFILLER_0_39_54 VGND VGND VPWR VPWR sky130_fd_sc_hd__fill_2
X_3232_ VGND VGND VPWR VPWR _1671_ _0175_ _1836_ Nand_gate
X_3301_ VGND VGND VPWR VPWR _1648_ _0249_ _0250_ Nor_gate
XTAP_257 VGND VPWR sky130_fd_sc_hd__tapvpwrvgnd_1
XTAP_246 VGND VPWR sky130_fd_sc_hd__tapvpwrvgnd_1
XTAP_235 VGND VPWR sky130_fd_sc_hd__tapvpwrvgnd_1
X_4350_ VGND VGND VPWR VPWR net69 _1382_ _1383_ Nor_gate
XTAP_202 VGND VPWR sky130_fd_sc_hd__tapvpwrvgnd_1
XTAP_213 VGND VPWR sky130_fd_sc_hd__tapvpwrvgnd_1
XTAP_224 VGND VPWR sky130_fd_sc_hd__tapvpwrvgnd_1
XFILLER_0_55_97 VPWR VGND VPWR VGND sky130_ef_sc_hd__decap_12
XFILLER_0_55_53 VGND VGND VPWR VPWR sky130_fd_sc_hd__decap_3
XTAP_279 VGND VPWR sky130_fd_sc_hd__tapvpwrvgnd_1
XTAP_268 VGND VPWR sky130_fd_sc_hd__tapvpwrvgnd_1
X_3094_ VGND VGND VPWR VPWR _2138_ _0025_ _0024_ Nand_gate
X_3163_ VGND VGND VPWR VPWR _1690_ _0100_ _0099_ Nand_gate
X_3996_ VGND VGND VPWR VPWR _1001_ _0898_ _1000_ _2155_ Mux
X_2947_ VGND VGND VPWR VPWR _2051_ _1739_ _1732_ _1427_ Mux
XFILLER_0_17_302 VGND VGND VPWR VPWR sky130_fd_sc_hd__decap_3
XFILLER_0_44_187 VGND VGND VPWR VPWR sky130_fd_sc_hd__fill_1
X_2878_ VGND VGND VPWR VPWR _1982_ net27 _1983_ Nor_gate
XFILLER_0_4_273 VGND VGND VPWR VPWR sky130_fd_sc_hd__fill_2
XFILLER_0_35_121 VGND VGND VPWR VPWR sky130_fd_sc_hd__decap_3
XFILLER_0_25_45 VGND VGND VPWR VPWR sky130_fd_sc_hd__decap_8
X_3850_ VGND VGND VPWR VPWR _0844_ _0387_ _0452_ _1676_ Mux
X_2801_ VGND VGND VPWR VPWR _1907_ _1743_ _1748_ _1588_ Mux
XFILLER_0_26_121 VGND VGND VPWR VPWR sky130_fd_sc_hd__fill_2
X_3781_ VGND VGND VPWR VPWR _0733_ _0769_ _0606_ Nand_gate
X_2732_ VGND VGND VPWR VPWR _1839_ net19 net20 _1607_ Mux
X_2663_ VGND VGND VPWR VPWR _1771_ _1767_ _1770_ _1633_ Mux
XFILLER_0_41_146 VGND VGND VPWR VPWR sky130_fd_sc_hd__fill_1
XFILLER_0_41_113 VGND VGND VPWR VPWR sky130_fd_sc_hd__decap_6
XFILLER_0_41_88 VGND VGND VPWR VPWR sky130_fd_sc_hd__decap_3
X_2594_ VGND VGND VPWR VPWR _1700_ _1703_ _1702_ Nand_gate
XFILLER_0_14_305 VGND VGND VPWR VPWR sky130_fd_sc_hd__decap_3
XFILLER_0_14_316 VGND VGND VPWR VPWR sky130_fd_sc_hd__fill_1
X_4195_ VGND VGND VPWR VPWR _1216_ _1001_ _1215_ _1870_ Mux
X_4333_ VGND VGND VPWR VPWR _1354_ _1365_ _1364_ Nand_gate
X_4264_ VGND VGND VPWR VPWR _1289_ _1290_ _1246_ Nand_gate
XFILLER_0_5_55 VGND VGND VPWR VPWR sky130_fd_sc_hd__fill_1
X_3215_ VPWR VGND VGND VPWR _0150_ _0156_ _0155_ Xnor
XFILLER_0_10_3 VPWR VGND VPWR VGND sky130_ef_sc_hd__decap_12
X_3077_ VGND VGND VPWR VPWR _0000_ _0009_ _0008_ Nand_gate
X_3146_ VGND VGND VPWR VPWR _1133_ _0081_ _0082_ Nor_gate
XFILLER_0_57_290 VPWR VGND VPWR VGND sky130_ef_sc_hd__decap_12
XFILLER_0_49_279 VGND VGND VPWR VPWR sky130_fd_sc_hd__fill_1
XFILLER_0_32_124 VGND VGND VPWR VPWR sky130_fd_sc_hd__decap_8
X_3979_ VGND VGND VPWR VPWR _0980_ _0982_ _0983_ Nor_gate
XFILLER_0_17_121 VGND VGND VPWR VPWR sky130_fd_sc_hd__decap_3
XFILLER_0_17_187 VGND VGND VPWR VPWR sky130_fd_sc_hd__decap_8
XFILLER_0_32_135 VGND VGND VPWR VPWR sky130_fd_sc_hd__decap_4
XFILLER_0_55_249 VGND VGND VPWR VPWR sky130_fd_sc_hd__fill_1
XFILLER_0_23_113 VGND VGND VPWR VPWR sky130_fd_sc_hd__fill_1
XFILLER_0_11_308 VGND VGND VPWR VPWR sky130_fd_sc_hd__decap_6
X_3000_ VGND VGND VPWR VPWR _1924_ _2102_ _2103_ Nor_gate
XFILLER_0_36_88 VGND VGND VPWR VPWR sky130_fd_sc_hd__decap_3
Xinput7 a[15] VGND VGND VPWR VPWR net7 sky130_fd_sc_hd__clkbuf_2
X_3902_ VGND VGND VPWR VPWR _0900_ _0697_ _0899_ _0379_ Mux
XFILLER_0_54_271 VGND VGND VPWR VPWR sky130_fd_sc_hd__fill_1
X_3764_ VGND VGND VPWR VPWR _0743_ _0750_ _0751_ Nor_gate
X_3833_ VGND VGND VPWR VPWR _0823_ _0824_ _0825_ Nor_gate
XFILLER_0_6_313 VGND VGND VPWR VPWR sky130_fd_sc_hd__fill_1
XFILLER_0_6_335 VGND VGND VPWR VPWR sky130_fd_sc_hd__decap_8
XFILLER_0_14_102 VGND VGND VPWR VPWR sky130_fd_sc_hd__decap_6
X_2646_ VGND VGND VPWR VPWR _1608_ _1753_ _1754_ Nor_gate
X_2715_ VGND VGND VPWR VPWR _1713_ _1822_ _1821_ Nand_gate
X_2577_ VGND VGND VPWR VPWR _1682_ _1685_ _1686_ Nor_gate
X_3695_ _1690_ VGND VGND VPWR VPWR _0676_ sky130_fd_sc_hd__clkbuf_4
X_4316_ VGND VGND VPWR VPWR _1346_ _1155_ _1345_ _0379_ Mux
X_4178_ VGND VGND VPWR VPWR _1136_ _1196_ _1198_ Nor_gate
X_4247_ VGND VGND VPWR VPWR _1272_ _0512_ _0513_ _0159_ Mux
XFILLER_0_37_249 VGND VGND VPWR VPWR sky130_fd_sc_hd__fill_1
XFILLER_0_37_216 VGND VGND VPWR VPWR sky130_fd_sc_hd__decap_8
X_3129_ VGND VGND VPWR VPWR _1671_ _1670_ _0064_ Nor_gate
XFILLER_0_20_149 VGND VGND VPWR VPWR sky130_fd_sc_hd__fill_2
XPHY_91 VGND VGND VPWR VPWR sky130_fd_sc_hd__decap_3
XPHY_80 VGND VGND VPWR VPWR sky130_fd_sc_hd__decap_3
XFILLER_0_36_271 VPWR VGND VPWR VGND sky130_ef_sc_hd__decap_12
XFILLER_0_28_227 VGND VGND VPWR VPWR sky130_fd_sc_hd__fill_2
XFILLER_0_51_285 VGND VGND VPWR VPWR sky130_fd_sc_hd__fill_1
XFILLER_0_51_274 VGND VGND VPWR VPWR sky130_fd_sc_hd__decap_6
X_2500_ VGND VGND VPWR VPWR _1609_ net27 _1410_ _1608_ Mux
X_3480_ VGND VGND VPWR VPWR _0444_ _1985_ _1984_ _0873_ Mux
X_2431_ VGND VGND VPWR VPWR _1528_ _1539_ _1540_ Nor_gate
XFILLER_0_47_43 VGND VGND VPWR VPWR sky130_fd_sc_hd__fill_1
X_4101_ VGND VGND VPWR VPWR _1115_ _2147_ _0187_ _0738_ Mux
X_4032_ VGND VGND VPWR VPWR _1037_ _1039_ _1040_ Nor_gate
X_2293_ VGND VGND VPWR VPWR _1337_ _1359_ _1348_ Nand_gate
X_2362_ VGND VGND VPWR VPWR _1471_ net39 inverter
XFILLER_0_19_238 VGND VGND VPWR VPWR sky130_fd_sc_hd__decap_6
X_3816_ VGND VGND VPWR VPWR _0795_ _0806_ _0807_ Nor_gate
XFILLER_0_34_219 VGND VGND VPWR VPWR sky130_fd_sc_hd__decap_8
X_3747_ VGND VGND VPWR VPWR _0113_ _0731_ _0732_ Nor_gate
XFILLER_0_27_260 VPWR VGND VPWR VGND sky130_ef_sc_hd__decap_12
XFILLER_0_6_132 VGND VGND VPWR VPWR sky130_fd_sc_hd__fill_2
X_2629_ VGND VGND VPWR VPWR _1737_ _0733_ _0679_ _1610_ Mux
X_3678_ VGND VGND VPWR VPWR _0609_ _0656_ _0658_ Nor_gate
XFILLER_0_10_160 VGND VGND VPWR VPWR sky130_fd_sc_hd__decap_3
X_2980_ VGND VGND VPWR VPWR _1812_ _2082_ _2083_ Nor_gate
XFILLER_0_33_45 VGND VGND VPWR VPWR sky130_fd_sc_hd__decap_3
XFILLER_0_17_68 VGND VGND VPWR VPWR sky130_fd_sc_hd__fill_2
XFILLER_0_17_79 VGND VGND VPWR VPWR sky130_fd_sc_hd__fill_2
Xinput43 b[15] VGND VGND VPWR VPWR net43 sky130_fd_sc_hd__buf_2
XFILLER_0_56_333 VGND VGND VPWR VPWR sky130_fd_sc_hd__decap_8
X_3601_ VGND VGND VPWR VPWR _0575_ _0449_ _0574_ _1938_ Mux
Xinput32 a[9] VGND VGND VPWR VPWR net32 sky130_fd_sc_hd__buf_2
Xinput21 a[28] VGND VGND VPWR VPWR net21 sky130_fd_sc_hd__buf_2
Xinput54 b[25] VGND VGND VPWR VPWR net54 sky130_fd_sc_hd__buf_2
XFILLER_0_24_230 VGND VGND VPWR VPWR sky130_fd_sc_hd__fill_2
XFILLER_0_3_113 VGND VGND VPWR VPWR sky130_fd_sc_hd__fill_2
Xinput10 a[18] VGND VGND VPWR VPWR net10 sky130_fd_sc_hd__buf_1
XFILLER_0_58_20 VGND VGND VPWR VPWR sky130_fd_sc_hd__decap_4
X_3532_ VGND VGND VPWR VPWR _0500_ _0252_ inverter
Xinput65 b[6] VGND VGND VPWR VPWR net65 sky130_fd_sc_hd__clkbuf_2
X_3394_ VGND VGND VPWR VPWR _0343_ _0351_ _0350_ Nand_gate
X_3463_ VGND VGND VPWR VPWR _0424_ _0360_ _0425_ Nor_gate
X_2414_ VGND VGND VPWR VPWR _1510_ _1522_ _1523_ Nor_gate
X_4015_ VGND VGND VPWR VPWR _1013_ _1022_ _1021_ Nand_gate
X_2345_ VGND VGND VPWR VPWR net29 net65 _1454_ Nor_gate
X_2276_ VGND VGND VPWR VPWR _1122_ _1165_ _1176_ Nor_gate
XFILLER_0_30_299 VGND VGND VPWR VPWR sky130_fd_sc_hd__decap_8
XFILLER_0_53_314 VPWR VGND VPWR VGND sky130_ef_sc_hd__decap_12
XTAP_439 VGND VPWR sky130_fd_sc_hd__tapvpwrvgnd_1
XTAP_428 VGND VPWR sky130_fd_sc_hd__tapvpwrvgnd_1
XTAP_417 VGND VPWR sky130_fd_sc_hd__tapvpwrvgnd_1
XTAP_406 VGND VPWR sky130_fd_sc_hd__tapvpwrvgnd_1
XFILLER_0_21_222 VGND VGND VPWR VPWR sky130_fd_sc_hd__fill_2
XFILLER_0_56_141 VGND VGND VPWR VPWR sky130_fd_sc_hd__decap_4
XFILLER_0_44_88 VGND VGND VPWR VPWR sky130_fd_sc_hd__decap_8
X_2963_ VGND VGND VPWR VPWR _2044_ _2066_ _2067_ Nor_gate
XFILLER_0_8_205 VGND VGND VPWR VPWR sky130_fd_sc_hd__fill_1
XFILLER_0_8_227 VGND VGND VPWR VPWR sky130_fd_sc_hd__fill_1
X_2894_ VGND VGND VPWR VPWR _1996_ _1998_ _1999_ Nor_gate
X_3515_ VPWR VGND VGND VPWR _1014_ _0481_ _0480_ Xnor
X_3446_ VGND VGND VPWR VPWR _0407_ _0401_ _0406_ _0135_ Mux
X_3377_ VGND VGND VPWR VPWR _0332_ _0049_ _0331_ _1605_ Mux
XFILLER_0_40_3 VPWR VGND VPWR VGND sky130_ef_sc_hd__decap_12
X_2328_ VGND VGND VPWR VPWR _1430_ _1436_ _1437_ Nor_gate
X_2259_ VGND VGND VPWR VPWR _0992_ _0981_ inverter
XFILLER_0_47_130 VGND VGND VPWR VPWR sky130_fd_sc_hd__fill_1
XFILLER_0_14_36 VGND VGND VPWR VPWR sky130_fd_sc_hd__decap_3
XFILLER_0_14_69 VGND VGND VPWR VPWR sky130_fd_sc_hd__fill_1
XFILLER_0_53_188 VGND VGND VPWR VPWR sky130_fd_sc_hd__decap_6
XFILLER_0_53_144 VGND VGND VPWR VPWR sky130_fd_sc_hd__fill_1
XFILLER_0_53_122 VGND VGND VPWR VPWR sky130_fd_sc_hd__decap_6
XFILLER_0_26_325 VGND VGND VPWR VPWR sky130_fd_sc_hd__fill_1
XFILLER_0_5_208 VGND VGND VPWR VPWR sky130_fd_sc_hd__decap_8
X_4280_ VGND VGND VPWR VPWR _0686_ _1307_ _1308_ Nor_gate
XFILLER_0_39_88 VGND VGND VPWR VPWR sky130_fd_sc_hd__decap_6
XFILLER_0_39_33 VGND VGND VPWR VPWR sky130_fd_sc_hd__fill_1
XFILLER_0_39_22 VGND VGND VPWR VPWR sky130_fd_sc_hd__decap_4
X_3231_ VGND VGND VPWR VPWR _1624_ _1830_ _0174_ Nor_gate
X_3300_ VGND VGND VPWR VPWR _0243_ _0248_ _0249_ Nor_gate
XTAP_269 VGND VPWR sky130_fd_sc_hd__tapvpwrvgnd_1
XTAP_258 VGND VPWR sky130_fd_sc_hd__tapvpwrvgnd_1
XTAP_247 VGND VPWR sky130_fd_sc_hd__tapvpwrvgnd_1
XTAP_236 VGND VPWR sky130_fd_sc_hd__tapvpwrvgnd_1
X_3162_ VGND VGND VPWR VPWR _0096_ _0099_ _0097_ Nand_gate
XTAP_203 VGND VPWR sky130_fd_sc_hd__tapvpwrvgnd_1
XTAP_214 VGND VPWR sky130_fd_sc_hd__tapvpwrvgnd_1
XTAP_225 VGND VPWR sky130_fd_sc_hd__tapvpwrvgnd_1
XFILLER_0_55_65 VGND VGND VPWR VPWR sky130_fd_sc_hd__decap_8
XFILLER_0_55_21 VPWR VGND VPWR VGND sky130_ef_sc_hd__decap_12
X_3093_ VGND VGND VPWR VPWR _1316_ _0024_ _0023_ Nand_gate
X_3995_ VGND VGND VPWR VPWR _1000_ net17 net16 _1608_ Mux
XFILLER_0_44_122 VGND VGND VPWR VPWR sky130_fd_sc_hd__fill_2
X_2946_ VGND VGND VPWR VPWR _2050_ _1717_ _1729_ _1712_ Mux
X_2877_ _1636_ VGND VGND VPWR VPWR _1982_ sky130_fd_sc_hd__clkbuf_4
XFILLER_0_29_185 VGND VGND VPWR VPWR sky130_fd_sc_hd__decap_8
XFILLER_0_17_314 VGND VGND VPWR VPWR sky130_fd_sc_hd__fill_1
X_3429_ VGND VGND VPWR VPWR _1637_ _1755_ _0389_ Nor_gate
XFILLER_0_35_166 VGND VGND VPWR VPWR sky130_fd_sc_hd__fill_2
XFILLER_0_58_225 VGND VGND VPWR VPWR sky130_fd_sc_hd__decap_8
XFILLER_0_25_79 VGND VGND VPWR VPWR sky130_fd_sc_hd__decap_3
XFILLER_0_25_57 VPWR VGND VPWR VGND sky130_ef_sc_hd__decap_12
X_2800_ VGND VGND VPWR VPWR _1906_ _1905_ inverter
X_2731_ VGND VGND VPWR VPWR _1838_ _1837_ inverter
XFILLER_0_26_133 VGND VGND VPWR VPWR sky130_fd_sc_hd__decap_6
X_3780_ VGND VGND VPWR VPWR _0768_ _0609_ inverter
X_2662_ VGND VGND VPWR VPWR _1769_ _1770_ _1753_ Nand_gate
XFILLER_0_41_169 VGND VGND VPWR VPWR sky130_fd_sc_hd__decap_4
X_2593_ VGND VGND VPWR VPWR _1701_ _1679_ _1702_ Nor_gate
X_4332_ VGND VGND VPWR VPWR _1355_ _1363_ _1364_ Nor_gate
X_4194_ VGND VGND VPWR VPWR _1215_ _1107_ _1214_ _0255_ Mux
X_4263_ VGND VGND VPWR VPWR _1289_ _1248_ inverter
X_3214_ VPWR VGND VGND VPWR net38 _0155_ _0154_ Xnor
X_3145_ VGND VGND VPWR VPWR _0078_ _0080_ _0081_ Nor_gate
XFILLER_0_9_333 VGND VGND VPWR VPWR sky130_fd_sc_hd__decap_3
X_3076_ VGND VGND VPWR VPWR _0002_ _0007_ _0008_ Nor_gate
X_2929_ VGND VGND VPWR VPWR _1624_ _2032_ _2033_ Nor_gate
X_3978_ VGND VGND VPWR VPWR net17 _0978_ _0982_ Nor_gate
XFILLER_0_23_169 VGND VGND VPWR VPWR sky130_fd_sc_hd__fill_2
XFILLER_0_11_48 VGND VGND VPWR VPWR sky130_fd_sc_hd__fill_2
Xinput8 a[16] VGND VGND VPWR VPWR net8 sky130_fd_sc_hd__clkbuf_2
X_3901_ VGND VGND VPWR VPWR _0899_ _0796_ _0898_ _0255_ Mux
XFILLER_0_46_239 VGND VGND VPWR VPWR sky130_fd_sc_hd__decap_3
X_2714_ VGND VGND VPWR VPWR _1821_ _1611_ _1626_ _1716_ Mux
X_3763_ VGND VGND VPWR VPWR _0748_ _0750_ _0749_ Nand_gate
X_3694_ VGND VGND VPWR VPWR _0655_ _0674_ _0675_ Nor_gate
X_3832_ VGND VGND VPWR VPWR _0387_ _0821_ _0824_ Nor_gate
XFILLER_0_14_114 VGND VGND VPWR VPWR sky130_fd_sc_hd__fill_1
X_4315_ VGND VGND VPWR VPWR _1345_ _1259_ _1344_ _0255_ Mux
X_2645_ VGND VGND VPWR VPWR _1588_ _1753_ net25 Nand_gate
X_2576_ VGND VGND VPWR VPWR _1434_ _1684_ _1685_ Nor_gate
XFILLER_0_10_331 VPWR VGND VPWR VGND sky130_ef_sc_hd__decap_12
XFILLER_0_14_169 VGND VGND VPWR VPWR sky130_fd_sc_hd__fill_1
X_4177_ VGND VGND VPWR VPWR _1167_ _0355_ _1196_ Nor_gate
X_3128_ VGND VGND VPWR VPWR _0063_ _2148_ inverter
X_4246_ VGND VGND VPWR VPWR _0389_ _1271_ _0741_ Nand_gate
X_3059_ VGND VGND VPWR VPWR _2161_ _1905_ _1929_ _1606_ Mux
XFILLER_0_45_250 VGND VGND VPWR VPWR sky130_fd_sc_hd__decap_4
XFILLER_0_20_139 VGND VGND VPWR VPWR sky130_fd_sc_hd__fill_1
XPHY_92 VGND VGND VPWR VPWR sky130_fd_sc_hd__decap_3
XPHY_81 VGND VGND VPWR VPWR sky130_fd_sc_hd__decap_3
XFILLER_0_36_283 VGND VGND VPWR VPWR sky130_fd_sc_hd__decap_3
XFILLER_0_36_250 VGND VGND VPWR VPWR sky130_fd_sc_hd__fill_2
XPHY_70 VGND VGND VPWR VPWR sky130_fd_sc_hd__decap_3
XFILLER_0_28_217 VGND VGND VPWR VPWR sky130_fd_sc_hd__fill_1
XFILLER_0_22_58 VGND VGND VPWR VPWR sky130_fd_sc_hd__fill_1
X_2361_ VGND VGND VPWR VPWR _1305_ _1470_ _1469_ Nand_gate
XFILLER_0_11_139 VGND VGND VPWR VPWR sky130_fd_sc_hd__decap_6
X_2430_ VGND VGND VPWR VPWR _0538_ _1538_ _1539_ Nor_gate
X_4100_ VGND VGND VPWR VPWR _1862_ _1113_ _1114_ Nor_gate
X_4031_ VGND VGND VPWR VPWR _0676_ _1039_ _1038_ Nand_gate
X_2292_ VGND VGND VPWR VPWR _1348_ net66 inverter
XFILLER_0_42_253 VGND VGND VPWR VPWR sky130_fd_sc_hd__decap_3
X_3815_ VGND VGND VPWR VPWR _0806_ _0805_ inverter
X_3746_ VGND VGND VPWR VPWR _0519_ _0730_ _0731_ Nor_gate
XFILLER_0_27_272 VGND VGND VPWR VPWR sky130_fd_sc_hd__decap_8
X_3677_ VGND VGND VPWR VPWR _0559_ _0608_ _0656_ Nor_gate
XFILLER_0_6_144 VGND VGND VPWR VPWR sky130_fd_sc_hd__decap_6
XFILLER_0_6_166 VGND VGND VPWR VPWR sky130_fd_sc_hd__decap_6
X_2628_ VGND VGND VPWR VPWR _1725_ _1736_ _1735_ Nand_gate
X_2559_ VGND VGND VPWR VPWR _1668_ _0094_ _0040_ _1667_ Mux
X_4229_ VGND VGND VPWR VPWR _0676_ _1253_ _1252_ Nand_gate
XFILLER_0_10_172 VPWR VGND VPWR VGND sky130_ef_sc_hd__decap_12
XFILLER_0_33_253 VPWR VGND VPWR VGND sky130_ef_sc_hd__decap_12
XFILLER_0_0_309 VGND VGND VPWR VPWR sky130_fd_sc_hd__decap_8
XFILLER_0_33_57 VGND VGND VPWR VPWR sky130_fd_sc_hd__fill_2
Xinput44 b[16] VGND VGND VPWR VPWR net44 sky130_fd_sc_hd__clkbuf_4
Xinput55 b[26] VGND VGND VPWR VPWR net55 sky130_fd_sc_hd__clkbuf_4
Xinput66 b[7] VGND VGND VPWR VPWR net66 sky130_fd_sc_hd__clkbuf_2
X_3600_ VGND VGND VPWR VPWR _0574_ _0787_ _1014_ _1667_ Mux
X_3531_ VGND VGND VPWR VPWR _1924_ _0498_ _0499_ Nor_gate
XFILLER_0_24_275 VPWR VGND VPWR VGND sky130_ef_sc_hd__decap_12
XFILLER_0_24_253 VPWR VGND VPWR VGND sky130_ef_sc_hd__decap_12
XFILLER_0_3_169 VGND VGND VPWR VPWR sky130_fd_sc_hd__fill_2
XFILLER_0_3_136 VGND VGND VPWR VPWR sky130_fd_sc_hd__decap_3
Xinput11 a[19] VGND VGND VPWR VPWR net11 sky130_fd_sc_hd__clkbuf_2
Xinput22 a[29] VGND VGND VPWR VPWR net22 sky130_fd_sc_hd__clkbuf_2
Xinput33 alu_control[0] VGND VGND VPWR VPWR net33 sky130_fd_sc_hd__buf_2
XFILLER_0_58_65 VGND VGND VPWR VPWR sky130_fd_sc_hd__decap_8
X_3393_ VGND VGND VPWR VPWR _1766_ _0350_ _0349_ Nand_gate
X_2344_ VGND VGND VPWR VPWR net29 _1391_ _1453_ Nor_gate
X_3462_ VGND VGND VPWR VPWR _0424_ _1491_ inverter
X_2413_ VGND VGND VPWR VPWR _1513_ _1521_ _1522_ Nor_gate
X_4014_ VGND VGND VPWR VPWR _1015_ _1020_ _1021_ Nor_gate
X_2275_ VGND VGND VPWR VPWR _1133_ _1154_ _1165_ Nor_gate
XFILLER_0_47_345 VGND VGND VPWR VPWR sky130_fd_sc_hd__fill_2
XFILLER_0_30_256 VPWR VGND VPWR VGND sky130_ef_sc_hd__decap_12
XFILLER_0_30_223 VGND VGND VPWR VPWR sky130_fd_sc_hd__decap_4
X_3729_ VGND VGND VPWR VPWR net78 _0713_ inverter
XFILLER_0_53_337 VGND VGND VPWR VPWR sky130_fd_sc_hd__decap_8
XFILLER_0_53_326 VGND VGND VPWR VPWR sky130_fd_sc_hd__decap_8
XTAP_429 VGND VPWR sky130_fd_sc_hd__tapvpwrvgnd_1
XTAP_418 VGND VPWR sky130_fd_sc_hd__tapvpwrvgnd_1
XTAP_407 VGND VPWR sky130_fd_sc_hd__tapvpwrvgnd_1
XFILLER_0_21_278 VGND VGND VPWR VPWR sky130_fd_sc_hd__fill_2
XFILLER_0_56_197 VGND VGND VPWR VPWR sky130_fd_sc_hd__decap_4
XFILLER_0_56_164 VGND VGND VPWR VPWR sky130_fd_sc_hd__decap_4
XFILLER_0_44_304 VGND VGND VPWR VPWR sky130_fd_sc_hd__decap_4
X_2893_ VGND VGND VPWR VPWR _1644_ _1997_ _1998_ Nor_gate
X_2962_ VGND VGND VPWR VPWR _2055_ _2066_ _2065_ Nand_gate
X_3445_ VGND VGND VPWR VPWR _0406_ _0402_ _0405_ _1870_ Mux
X_3514_ VPWR VGND VGND VPWR net43 _0480_ _0479_ Xnor
XFILLER_0_8_56 VGND VGND VPWR VPWR sky130_fd_sc_hd__fill_2
XFILLER_0_8_67 VGND VGND VPWR VPWR sky130_fd_sc_hd__decap_3
X_3376_ VGND VGND VPWR VPWR _0331_ _0328_ _0330_ _1938_ Mux
X_2327_ VGND VGND VPWR VPWR _1432_ _1435_ _1436_ Nor_gate
XFILLER_0_33_3 VGND VGND VPWR VPWR sky130_fd_sc_hd__decap_4
X_2258_ VGND VGND VPWR VPWR _0959_ _0981_ net40 Nand_gate
X_2189_ VGND VGND VPWR VPWR _0149_ _0224_ _0235_ Nor_gate
XFILLER_0_50_307 VGND VGND VPWR VPWR sky130_fd_sc_hd__fill_1
XFILLER_0_35_337 VGND VGND VPWR VPWR sky130_fd_sc_hd__fill_1
XFILLER_0_38_153 VGND VGND VPWR VPWR sky130_fd_sc_hd__fill_1
XFILLER_0_53_178 VGND VGND VPWR VPWR sky130_fd_sc_hd__fill_1
XFILLER_0_55_33 VPWR VGND VPWR VGND sky130_ef_sc_hd__decap_12
XTAP_259 VGND VPWR sky130_fd_sc_hd__tapvpwrvgnd_1
XTAP_248 VGND VPWR sky130_fd_sc_hd__tapvpwrvgnd_1
XTAP_237 VGND VPWR sky130_fd_sc_hd__tapvpwrvgnd_1
X_3161_ VGND VGND VPWR VPWR _0096_ _0097_ _0098_ Nor_gate
X_3230_ VGND VGND VPWR VPWR _0169_ _0173_ _0172_ Nand_gate
XTAP_204 VGND VPWR sky130_fd_sc_hd__tapvpwrvgnd_1
XTAP_215 VGND VPWR sky130_fd_sc_hd__tapvpwrvgnd_1
XTAP_226 VGND VPWR sky130_fd_sc_hd__tapvpwrvgnd_1
X_3092_ VGND VGND VPWR VPWR _0023_ _2136_ inverter
X_3994_ VGND VGND VPWR VPWR _0229_ _0999_ _0998_ Nand_gate
X_2945_ VGND VGND VPWR VPWR _2045_ _2049_ _2048_ Nand_gate
XFILLER_0_32_307 VGND VGND VPWR VPWR sky130_fd_sc_hd__fill_1
X_2876_ VGND VGND VPWR VPWR _1978_ _1980_ _1981_ Nor_gate
XFILLER_0_17_337 VGND VGND VPWR VPWR sky130_fd_sc_hd__decap_8
X_3428_ VGND VGND VPWR VPWR _0375_ _0388_ _0386_ Nand_gate
XFILLER_0_20_91 VPWR VGND VPWR VGND sky130_ef_sc_hd__decap_12
X_3359_ VGND VGND VPWR VPWR _1669_ _1637_ _0313_ Nor_gate
XFILLER_0_35_189 VGND VGND VPWR VPWR sky130_fd_sc_hd__fill_2
XFILLER_0_58_237 VPWR VGND VPWR VGND sky130_ef_sc_hd__decap_12
XFILLER_0_25_69 VGND VGND VPWR VPWR sky130_fd_sc_hd__decap_6
XFILLER_0_58_259 VGND VGND VPWR VPWR sky130_fd_sc_hd__decap_4
X_2661_ VGND VGND VPWR VPWR _1432_ _1769_ _1768_ Nand_gate
X_2730_ VGND VGND VPWR VPWR _1624_ _1836_ _1837_ Nor_gate
XFILLER_0_26_145 VGND VGND VPWR VPWR sky130_fd_sc_hd__fill_1
XFILLER_0_41_159 VGND VGND VPWR VPWR sky130_fd_sc_hd__decap_6
X_2592_ VGND VGND VPWR VPWR _1645_ _1701_ net36 Nand_gate
X_4262_ VPWR VGND VGND VPWR _0094_ _1288_ _1287_ Xnor
X_4331_ VGND VGND VPWR VPWR _1357_ _1363_ _1362_ Nand_gate
XFILLER_0_1_223 VGND VGND VPWR VPWR sky130_fd_sc_hd__fill_1
X_4193_ VGND VGND VPWR VPWR _1214_ net21 net20 _1676_ Mux
X_3075_ VGND VGND VPWR VPWR _1451_ _0006_ _0007_ Nor_gate
XFILLER_0_5_57 VGND VGND VPWR VPWR sky130_fd_sc_hd__fill_2
X_3213_ VGND VGND VPWR VPWR _0151_ _0154_ _0153_ Nand_gate
X_3144_ VGND VGND VPWR VPWR _1880_ _0080_ _0079_ Nand_gate
XFILLER_0_49_237 VGND VGND VPWR VPWR sky130_fd_sc_hd__fill_2
X_3977_ VGND VGND VPWR VPWR _0980_ _0979_ inverter
X_2928_ VGND VGND VPWR VPWR _2032_ _1744_ _1750_ _1712_ Mux
X_2859_ VGND VGND VPWR VPWR _1964_ _1963_ inverter
XFILLER_0_48_270 VPWR VGND VPWR VGND sky130_ef_sc_hd__decap_12
XFILLER_0_36_68 VGND VGND VPWR VPWR sky130_fd_sc_hd__fill_1
Xinput9 a[17] VGND VGND VPWR VPWR net9 sky130_fd_sc_hd__buf_1
X_3900_ VGND VGND VPWR VPWR _0898_ _0333_ _0387_ _1608_ Mux
XFILLER_0_52_78 VGND VGND VPWR VPWR sky130_fd_sc_hd__decap_6
XFILLER_0_46_229 VGND VGND VPWR VPWR sky130_fd_sc_hd__fill_1
X_3831_ VGND VGND VPWR VPWR _1655_ _0822_ _0823_ Nor_gate
XFILLER_0_39_281 VGND VGND VPWR VPWR sky130_fd_sc_hd__decap_4
X_2644_ VGND VGND VPWR VPWR _1628_ _1751_ _1752_ Nor_gate
X_2713_ VGND VGND VPWR VPWR _1817_ _1819_ _1820_ Nor_gate
X_3762_ VGND VGND VPWR VPWR net47 _0749_ _0393_ Nand_gate
X_3693_ VGND VGND VPWR VPWR _0658_ _0673_ _0674_ Nor_gate
X_4314_ VGND VGND VPWR VPWR _1344_ _2147_ net24 _1676_ Mux
X_4245_ VGND VGND VPWR VPWR _0113_ _1269_ _1270_ Nor_gate
X_2575_ VGND VGND VPWR VPWR _1643_ _1684_ _1683_ Nand_gate
XFILLER_0_22_192 VGND VGND VPWR VPWR sky130_fd_sc_hd__decap_4
XFILLER_0_10_343 VGND VGND VPWR VPWR sky130_fd_sc_hd__decap_4
X_3058_ VGND VGND VPWR VPWR _2160_ _1926_ _1928_ _1713_ Mux
X_3127_ VGND VGND VPWR VPWR _0055_ _0060_ _0061_ Nor_gate
X_4176_ VGND VGND VPWR VPWR _1185_ _1194_ _1195_ Nor_gate
XFILLER_0_20_129 VGND VGND VPWR VPWR sky130_fd_sc_hd__fill_1
XPHY_82 VGND VGND VPWR VPWR sky130_fd_sc_hd__decap_3
XPHY_71 VGND VGND VPWR VPWR sky130_fd_sc_hd__decap_3
XPHY_60 VGND VGND VPWR VPWR sky130_fd_sc_hd__decap_3
XPHY_93 VGND VGND VPWR VPWR sky130_fd_sc_hd__decap_3
X_2360_ VGND VGND VPWR VPWR _1448_ _1469_ _1468_ Nand_gate
X_2291_ VGND VGND VPWR VPWR _1337_ _1316_ inverter
XFILLER_0_47_78 VGND VGND VPWR VPWR sky130_fd_sc_hd__decap_3
X_4030_ VGND VGND VPWR VPWR _1034_ _1038_ _1036_ Nand_gate
X_3814_ VGND VGND VPWR VPWR _1999_ _0805_ _0804_ Nand_gate
XFILLER_0_27_240 VPWR VGND VPWR VGND sky130_ef_sc_hd__decap_12
XFILLER_0_19_207 VGND VGND VPWR VPWR sky130_fd_sc_hd__fill_1
X_2627_ VGND VGND VPWR VPWR _1636_ _1734_ _1735_ Nor_gate
X_3745_ VGND VGND VPWR VPWR _0686_ _1916_ _0730_ Nor_gate
XFILLER_0_27_284 VGND VGND VPWR VPWR sky130_fd_sc_hd__decap_6
X_3676_ VPWR VGND VGND VPWR _0647_ _0655_ _0654_ Xnor
X_2558_ _1433_ VGND VGND VPWR VPWR _1667_ sky130_fd_sc_hd__buf_4
X_4228_ VGND VGND VPWR VPWR _1247_ _1252_ _1249_ Nand_gate
X_2489_ VGND VGND VPWR VPWR _0841_ _1598_ _1597_ Nand_gate
XFILLER_0_10_184 VGND VGND VPWR VPWR sky130_fd_sc_hd__fill_2
XFILLER_0_10_195 VGND VGND VPWR VPWR sky130_fd_sc_hd__fill_1
X_4159_ VGND VGND VPWR VPWR _1152_ _1178_ _1177_ Nand_gate
XFILLER_0_18_273 VGND VGND VPWR VPWR sky130_fd_sc_hd__fill_1
XFILLER_0_18_251 VGND VGND VPWR VPWR sky130_fd_sc_hd__fill_1
XFILLER_0_33_265 VPWR VGND VPWR VGND sky130_ef_sc_hd__decap_12
Xinput56 b[27] VGND VGND VPWR VPWR net56 sky130_fd_sc_hd__clkbuf_2
Xinput34 alu_control[1] VGND VGND VPWR VPWR net34 sky130_fd_sc_hd__buf_2
X_3530_ VGND VGND VPWR VPWR _0498_ _2145_ _0497_ _1614_ Mux
XFILLER_0_24_287 VGND VGND VPWR VPWR sky130_fd_sc_hd__decap_8
XFILLER_0_24_265 VGND VGND VPWR VPWR sky130_fd_sc_hd__fill_2
Xinput67 b[8] VGND VGND VPWR VPWR net67 sky130_fd_sc_hd__buf_2
Xinput45 b[17] VGND VGND VPWR VPWR net45 sky130_fd_sc_hd__clkbuf_2
Xinput12 a[1] VGND VGND VPWR VPWR net12 sky130_fd_sc_hd__clkbuf_4
Xinput23 a[2] VGND VGND VPWR VPWR net23 sky130_fd_sc_hd__clkbuf_2
X_3461_ VGND VGND VPWR VPWR _1491_ _0422_ _0423_ Nor_gate
XFILLER_0_58_77 VGND VGND VPWR VPWR sky130_fd_sc_hd__decap_6
XFILLER_0_58_55 VGND VGND VPWR VPWR sky130_fd_sc_hd__fill_1
X_4013_ VGND VGND VPWR VPWR _1016_ _1019_ _1020_ Nor_gate
X_3392_ VGND VGND VPWR VPWR _0318_ _0349_ _0348_ Nand_gate
X_2343_ VGND VGND VPWR VPWR _1450_ _1451_ _1452_ Nor_gate
X_2412_ VGND VGND VPWR VPWR _1514_ _1520_ _1521_ Nor_gate
X_2274_ VGND VGND VPWR VPWR _1154_ _1143_ inverter
XFILLER_0_30_268 VGND VGND VPWR VPWR sky130_fd_sc_hd__decap_8
XFILLER_0_2_181 VGND VGND VPWR VPWR sky130_fd_sc_hd__fill_2
X_3728_ VGND VGND VPWR VPWR _0680_ _0711_ _0713_ Nor_gate
X_3659_ VGND VGND VPWR VPWR _1516_ _0637_ _0638_ Nor_gate
XFILLER_0_15_287 VGND VGND VPWR VPWR sky130_fd_sc_hd__decap_4
XFILLER_0_15_298 VPWR VGND VPWR VGND sky130_ef_sc_hd__decap_12
XFILLER_0_38_346 VGND VGND VPWR VPWR sky130_fd_sc_hd__fill_1
XTAP_419 VGND VPWR sky130_fd_sc_hd__tapvpwrvgnd_1
XTAP_408 VGND VPWR sky130_fd_sc_hd__tapvpwrvgnd_1
X_2892_ VGND VGND VPWR VPWR _1419_ _1997_ _1913_ Nand_gate
XFILLER_0_29_335 VGND VGND VPWR VPWR sky130_fd_sc_hd__fill_1
X_2961_ VGND VGND VPWR VPWR _2058_ _2064_ _2065_ Nor_gate
X_3444_ VGND VGND VPWR VPWR _0405_ _0404_ inverter
X_3513_ VGND VGND VPWR VPWR _0418_ _0478_ _0479_ Nor_gate
X_3375_ VGND VGND VPWR VPWR _0330_ _0329_ _1494_ _1585_ Mux
X_2326_ VGND VGND VPWR VPWR _1433_ _1434_ _1435_ Nor_gate
XFILLER_0_26_3 VGND VGND VPWR VPWR sky130_fd_sc_hd__decap_4
X_2257_ VGND VGND VPWR VPWR _0959_ net40 _0970_ Nor_gate
XFILLER_0_35_305 VGND VGND VPWR VPWR sky130_fd_sc_hd__fill_1
X_2188_ VGND VGND VPWR VPWR _0203_ _0224_ _0214_ Nand_gate
XFILLER_0_7_240 VGND VGND VPWR VPWR sky130_fd_sc_hd__decap_8
XFILLER_0_7_284 VGND VGND VPWR VPWR sky130_fd_sc_hd__fill_1
XFILLER_0_14_27 VGND VGND VPWR VPWR sky130_fd_sc_hd__fill_1
XFILLER_0_26_305 VGND VGND VPWR VPWR sky130_fd_sc_hd__decap_3
XFILLER_0_39_46 VGND VGND VPWR VPWR sky130_fd_sc_hd__decap_8
XFILLER_0_30_48 VGND VGND VPWR VPWR sky130_fd_sc_hd__decap_6
XTAP_205 VGND VPWR sky130_fd_sc_hd__tapvpwrvgnd_1
XFILLER_0_55_45 VGND VGND VPWR VPWR sky130_fd_sc_hd__decap_8
XFILLER_0_39_79 VGND VGND VPWR VPWR sky130_fd_sc_hd__decap_3
XTAP_249 VGND VPWR sky130_fd_sc_hd__tapvpwrvgnd_1
XTAP_238 VGND VPWR sky130_fd_sc_hd__tapvpwrvgnd_1
X_3091_ VGND VGND VPWR VPWR _1337_ _0022_ _2136_ Nand_gate
X_3160_ VGND VGND VPWR VPWR _0036_ _0097_ _0041_ Nand_gate
XTAP_216 VGND VPWR sky130_fd_sc_hd__tapvpwrvgnd_1
XTAP_227 VGND VPWR sky130_fd_sc_hd__tapvpwrvgnd_1
X_3993_ VGND VGND VPWR VPWR _0998_ _0997_ _0575_ _1870_ Mux
XFILLER_0_29_154 VGND VGND VPWR VPWR sky130_fd_sc_hd__fill_1
X_2944_ VGND VGND VPWR VPWR _2048_ _1797_ _2047_ _1605_ Mux
XFILLER_0_44_179 VGND VGND VPWR VPWR sky130_fd_sc_hd__fill_1
XFILLER_0_44_157 VGND VGND VPWR VPWR sky130_fd_sc_hd__decap_6
X_2875_ VGND VGND VPWR VPWR _1705_ _1980_ _1979_ Nand_gate
X_3427_ VGND VGND VPWR VPWR _0108_ _0374_ _0386_ Nor_gate
X_3358_ VGND VGND VPWR VPWR _0308_ _0312_ _0310_ Nand_gate
X_3289_ VGND VGND VPWR VPWR _0135_ _0237_ _0236_ Nand_gate
XFILLER_0_29_90 VGND VGND VPWR VPWR sky130_fd_sc_hd__fill_2
X_2309_ VGND VGND VPWR VPWR _1409_ _1417_ _1418_ Nor_gate
XFILLER_0_35_113 VGND VGND VPWR VPWR sky130_fd_sc_hd__decap_8
XFILLER_0_0_91 VPWR VGND VPWR VGND sky130_ef_sc_hd__decap_12
XFILLER_0_58_249 VGND VGND VPWR VPWR sky130_fd_sc_hd__decap_3
XFILLER_0_58_205 VGND VGND VPWR VPWR sky130_fd_sc_hd__fill_1
X_2660_ VGND VGND VPWR VPWR _1768_ _1565_ net24 _1615_ Mux
XFILLER_0_34_190 VGND VGND VPWR VPWR sky130_fd_sc_hd__decap_6
X_2591_ net63 VGND VGND VPWR VPWR _1700_ sky130_fd_sc_hd__inv_2
X_4261_ VPWR VGND VGND VPWR _0105_ _1287_ _1286_ Xnor
X_4330_ VGND VGND VPWR VPWR _1360_ _1361_ _1362_ Nor_gate
XFILLER_0_1_279 VGND VGND VPWR VPWR sky130_fd_sc_hd__fill_1
X_3212_ VGND VGND VPWR VPWR _0033_ _0153_ _0152_ Nand_gate
XFILLER_0_49_205 VGND VGND VPWR VPWR sky130_fd_sc_hd__fill_1
X_4192_ VGND VGND VPWR VPWR _0686_ _1213_ _0334_ Nand_gate
X_3074_ VGND VGND VPWR VPWR _0003_ _0005_ _0006_ Nor_gate
X_3143_ VGND VGND VPWR VPWR _1143_ _0079_ _1693_ Nand_gate
X_3976_ VGND VGND VPWR VPWR net17 _0979_ _0978_ Nand_gate
X_2927_ VGND VGND VPWR VPWR _2028_ _2031_ _2030_ Nand_gate
XFILLER_0_15_81 VGND VGND VPWR VPWR sky130_fd_sc_hd__fill_1
XFILLER_0_17_113 VGND VGND VPWR VPWR sky130_fd_sc_hd__decap_8
XFILLER_0_17_146 VGND VGND VPWR VPWR sky130_fd_sc_hd__fill_2
X_2858_ VGND VGND VPWR VPWR _1959_ _1962_ _1963_ Nor_gate
X_2789_ VGND VGND VPWR VPWR _1895_ _1894_ inverter
XFILLER_0_32_116 VGND VGND VPWR VPWR sky130_fd_sc_hd__decap_4
XFILLER_0_40_182 VGND VGND VPWR VPWR sky130_fd_sc_hd__fill_2
XFILLER_0_48_282 VGND VGND VPWR VPWR sky130_fd_sc_hd__decap_6
XFILLER_0_11_39 VGND VGND VPWR VPWR sky130_fd_sc_hd__decap_3
X_3761_ VGND VGND VPWR VPWR _0748_ _0747_ inverter
X_3830_ VGND VGND VPWR VPWR _0822_ _0821_ inverter
X_2712_ VGND VGND VPWR VPWR _1690_ _1819_ _1818_ Nand_gate
X_2643_ VGND VGND VPWR VPWR _1751_ _0170_ _0094_ _1610_ Mux
X_2574_ VGND VGND VPWR VPWR net35 net36 _1683_ Nor_gate
XFILLER_0_22_171 VPWR VGND VPWR VGND sky130_ef_sc_hd__decap_12
X_3692_ VGND VGND VPWR VPWR _0671_ _0672_ _0673_ Nor_gate
XFILLER_0_10_300 VGND VGND VPWR VPWR sky130_fd_sc_hd__decap_8
X_4175_ VGND VGND VPWR VPWR _1187_ _1194_ _1193_ Nand_gate
X_4244_ VGND VGND VPWR VPWR _0519_ _1268_ _1269_ Nor_gate
X_4313_ VGND VGND VPWR VPWR _1340_ _1342_ _1343_ Nor_gate
X_3126_ VGND VGND VPWR VPWR _1924_ _0059_ _0060_ Nor_gate
X_3057_ VGND VGND VPWR VPWR _2011_ _2158_ _2159_ Nor_gate
X_3959_ VGND VGND VPWR VPWR _0870_ _0923_ _0961_ Nor_gate
XFILLER_0_9_132 VPWR VGND VPWR VGND sky130_ef_sc_hd__decap_12
XFILLER_0_20_119 VGND VGND VPWR VPWR sky130_fd_sc_hd__fill_1
XFILLER_0_13_193 VGND VGND VPWR VPWR sky130_fd_sc_hd__fill_1
XPHY_94 VGND VGND VPWR VPWR sky130_fd_sc_hd__decap_3
XPHY_83 VGND VGND VPWR VPWR sky130_fd_sc_hd__decap_3
XPHY_72 VGND VGND VPWR VPWR sky130_fd_sc_hd__decap_3
XPHY_61 VGND VGND VPWR VPWR sky130_fd_sc_hd__decap_3
XFILLER_0_28_208 VGND VGND VPWR VPWR sky130_fd_sc_hd__decap_6
XPHY_50 VGND VGND VPWR VPWR sky130_fd_sc_hd__decap_3
XFILLER_0_22_38 VGND VGND VPWR VPWR sky130_fd_sc_hd__fill_1
XFILLER_0_22_27 VGND VGND VPWR VPWR sky130_fd_sc_hd__fill_1
XFILLER_0_51_222 VGND VGND VPWR VPWR sky130_fd_sc_hd__fill_2
XFILLER_0_11_108 VGND VGND VPWR VPWR sky130_fd_sc_hd__decap_4
XFILLER_0_11_119 VPWR VGND VPWR VGND sky130_ef_sc_hd__decap_12
XFILLER_0_47_57 VGND VGND VPWR VPWR sky130_fd_sc_hd__decap_4
X_2290_ VGND VGND VPWR VPWR _1316_ _1327_ net66 Nand_gate
XFILLER_0_2_15 VPWR VGND VPWR VGND sky130_ef_sc_hd__decap_12
X_3813_ VGND VGND VPWR VPWR _0108_ _0803_ _0804_ Nor_gate
XFILLER_0_27_296 VGND VGND VPWR VPWR sky130_fd_sc_hd__decap_8
XFILLER_0_27_252 VGND VGND VPWR VPWR sky130_fd_sc_hd__decap_4
X_3744_ VGND VGND VPWR VPWR _0725_ _0729_ _0728_ Nand_gate
XFILLER_0_56_3 VPWR VGND VPWR VGND sky130_ef_sc_hd__decap_12
Xoutput100 net100 VGND VGND VPWR VPWR result[9] sky130_fd_sc_hd__clkbuf_4
X_2626_ VGND VGND VPWR VPWR _1726_ _1733_ _1734_ Nor_gate
X_2557_ VGND VGND VPWR VPWR _1666_ _1570_ _0170_ _1433_ Mux
XFILLER_0_2_341 VGND VGND VPWR VPWR sky130_fd_sc_hd__fill_2
X_3675_ VPWR VGND VGND VPWR net46 _0654_ _0653_ Xnor
XFILLER_0_10_141 VGND VGND VPWR VPWR sky130_fd_sc_hd__decap_8
XFILLER_0_10_152 VGND VGND VPWR VPWR sky130_fd_sc_hd__decap_8
XFILLER_0_37_90 VGND VGND VPWR VPWR sky130_fd_sc_hd__decap_6
X_4158_ VGND VGND VPWR VPWR _1160_ _1175_ _1177_ Nor_gate
X_4227_ VGND VGND VPWR VPWR _1247_ _1249_ _1250_ Nor_gate
X_2488_ VGND VGND VPWR VPWR _1583_ _1596_ _1597_ Nor_gate
X_4089_ VGND VGND VPWR VPWR _1098_ _1101_ _1102_ Nor_gate
X_3109_ _1898_ VGND VGND VPWR VPWR _0042_ sky130_fd_sc_hd__clkbuf_4
XFILLER_0_33_277 VGND VGND VPWR VPWR sky130_fd_sc_hd__decap_3
XFILLER_0_33_233 VGND VGND VPWR VPWR sky130_fd_sc_hd__decap_8
Xinput13 a[20] VGND VGND VPWR VPWR net13 sky130_fd_sc_hd__clkbuf_2
Xinput46 b[18] VGND VGND VPWR VPWR net46 sky130_fd_sc_hd__buf_2
Xinput24 a[30] VGND VGND VPWR VPWR net24 sky130_fd_sc_hd__clkbuf_4
X_3391_ VGND VGND VPWR VPWR _1650_ _0348_ _0347_ Nand_gate
XFILLER_0_24_222 VGND VGND VPWR VPWR sky130_fd_sc_hd__decap_8
Xinput68 b[9] VGND VGND VPWR VPWR net68 sky130_fd_sc_hd__clkbuf_2
XFILLER_0_3_105 VGND VGND VPWR VPWR sky130_fd_sc_hd__decap_6
Xinput57 b[28] VGND VGND VPWR VPWR net57 sky130_fd_sc_hd__buf_2
X_3460_ VPWR VGND VGND VPWR net41 _0422_ _0359_ Xnor
X_2411_ VGND VGND VPWR VPWR _1517_ _1519_ _1520_ Nor_gate
Xinput35 alu_control[2] VGND VGND VPWR VPWR net35 sky130_fd_sc_hd__clkbuf_2
X_4012_ VGND VGND VPWR VPWR _1682_ _1018_ _1019_ Nor_gate
XFILLER_0_28_7 VGND VGND VPWR VPWR sky130_fd_sc_hd__fill_1
X_2342_ VGND VGND VPWR VPWR _1316_ net66 _1451_ Nor_gate
X_2273_ VGND VGND VPWR VPWR net31 _1143_ net67 Nand_gate
X_3727_ VGND VGND VPWR VPWR _0685_ _0711_ _0710_ Nand_gate
XFILLER_0_15_222 VGND VGND VPWR VPWR sky130_fd_sc_hd__fill_2
XFILLER_0_15_255 VGND VGND VPWR VPWR sky130_fd_sc_hd__fill_1
XFILLER_0_15_266 VGND VGND VPWR VPWR sky130_fd_sc_hd__fill_2
X_2609_ VGND VGND VPWR VPWR _1717_ _1714_ _1715_ _1716_ Mux
X_3589_ VGND VGND VPWR VPWR _0559_ _0561_ _0562_ Nor_gate
X_3658_ VGND VGND VPWR VPWR _1682_ _0635_ _0637_ Nor_gate
XFILLER_0_21_203 VGND VGND VPWR VPWR sky130_fd_sc_hd__fill_1
XTAP_409 VGND VPWR sky130_fd_sc_hd__tapvpwrvgnd_1
XFILLER_0_28_59 VGND VGND VPWR VPWR sky130_fd_sc_hd__fill_2
XFILLER_0_28_26 VGND VGND VPWR VPWR sky130_fd_sc_hd__fill_2
XFILLER_0_56_122 VGND VGND VPWR VPWR sky130_fd_sc_hd__decap_4
X_2960_ VGND VGND VPWR VPWR _2059_ _2064_ _2063_ Nand_gate
XFILLER_0_56_155 VGND VGND VPWR VPWR sky130_fd_sc_hd__fill_1
X_2891_ VGND VGND VPWR VPWR _1924_ _1995_ _1996_ Nor_gate
X_3443_ VGND VGND VPWR VPWR _0404_ _0251_ _0403_ _1938_ Mux
X_3374_ VGND VGND VPWR VPWR _0329_ _1230_ inverter
XFILLER_0_20_291 VGND VGND VPWR VPWR sky130_fd_sc_hd__decap_3
X_3512_ VGND VGND VPWR VPWR _1489_ _0355_ _0478_ Nor_gate
X_2256_ net4 VGND VGND VPWR VPWR _0959_ sky130_fd_sc_hd__clkbuf_4
X_2325_ VGND VGND VPWR VPWR _1434_ net1 inverter
X_2187_ VPWR VGND VGND VPWR net21 _0214_ net57 Xnor
XFILLER_0_19_3 VGND VGND VPWR VPWR sky130_fd_sc_hd__fill_2
XFILLER_0_47_155 VPWR VGND VPWR VGND sky130_ef_sc_hd__decap_12
XFILLER_0_47_111 VGND VGND VPWR VPWR sky130_fd_sc_hd__fill_1
XFILLER_0_50_309 VPWR VGND VPWR VGND sky130_ef_sc_hd__decap_12
XFILLER_0_41_309 VGND VGND VPWR VPWR sky130_fd_sc_hd__fill_1
XTAP_239 VGND VPWR sky130_fd_sc_hd__tapvpwrvgnd_1
XTAP_206 VGND VPWR sky130_fd_sc_hd__tapvpwrvgnd_1
XTAP_217 VGND VPWR sky130_fd_sc_hd__tapvpwrvgnd_1
XTAP_228 VGND VPWR sky130_fd_sc_hd__tapvpwrvgnd_1
XFILLER_0_55_57 VGND VGND VPWR VPWR sky130_fd_sc_hd__fill_2
X_3090_ VGND VGND VPWR VPWR _0020_ _0014_ _0021_ Nor_gate
X_3992_ VGND VGND VPWR VPWR _0997_ _0331_ inverter
X_2943_ VGND VGND VPWR VPWR _2047_ _1936_ _2046_ _1432_ Mux
XFILLER_0_29_177 VGND VGND VPWR VPWR sky130_fd_sc_hd__fill_2
XFILLER_0_52_191 VGND VGND VPWR VPWR sky130_fd_sc_hd__decap_4
XFILLER_0_44_147 VGND VGND VPWR VPWR sky130_fd_sc_hd__fill_1
XFILLER_0_40_320 VPWR VGND VPWR VGND sky130_ef_sc_hd__decap_12
X_2874_ VGND VGND VPWR VPWR _1461_ _1979_ _1977_ Nand_gate
XFILLER_0_20_71 VGND VGND VPWR VPWR sky130_fd_sc_hd__decap_8
XFILLER_0_4_266 VGND VGND VPWR VPWR sky130_fd_sc_hd__decap_4
X_2308_ VGND VGND VPWR VPWR _1415_ _1417_ _1416_ Nand_gate
X_3426_ VGND VGND VPWR VPWR _0113_ _0384_ _0385_ Nor_gate
X_3357_ VGND VGND VPWR VPWR _0042_ _0309_ _0310_ Nor_gate
X_3288_ VGND VGND VPWR VPWR _0233_ _0236_ _0234_ Nand_gate
X_2239_ VGND VGND VPWR VPWR _0722_ _0776_ _0765_ Nand_gate
XFILLER_0_35_169 VGND VGND VPWR VPWR sky130_fd_sc_hd__fill_2
XFILLER_0_31_331 VGND VGND VPWR VPWR sky130_fd_sc_hd__decap_4
XFILLER_0_8_3 VPWR VGND VPWR VGND sky130_ef_sc_hd__decap_12
XFILLER_0_9_90 VGND VGND VPWR VPWR sky130_fd_sc_hd__decap_3
XFILLER_0_41_139 VGND VGND VPWR VPWR sky130_fd_sc_hd__fill_1
XFILLER_0_41_128 VGND VGND VPWR VPWR sky130_fd_sc_hd__fill_2
X_2590_ VGND VGND VPWR VPWR _1440_ _1699_ _1698_ Nand_gate
XFILLER_0_26_169 VGND VGND VPWR VPWR sky130_fd_sc_hd__fill_2
XFILLER_0_1_225 VPWR VGND VPWR VGND sky130_ef_sc_hd__decap_12
XFILLER_0_14_309 VGND VGND VPWR VPWR sky130_fd_sc_hd__fill_1
X_4191_ VGND VGND VPWR VPWR _1209_ _1211_ _1212_ Nor_gate
X_4260_ VGND VGND VPWR VPWR _1242_ _1285_ _1286_ Nor_gate
X_3142_ VGND VGND VPWR VPWR _1143_ _1684_ _0078_ Nor_gate
XFILLER_0_5_15 VPWR VGND VPWR VGND sky130_ef_sc_hd__decap_12
X_3211_ VGND VGND VPWR VPWR net68 net67 _0152_ Nor_gate
X_3073_ VGND VGND VPWR VPWR _1880_ _0005_ _0004_ Nand_gate
X_2857_ VGND VGND VPWR VPWR _1895_ _1961_ _1962_ Nor_gate
X_3975_ VPWR VGND VGND VPWR net53 _0978_ _0977_ Xnor
X_2926_ VGND VGND VPWR VPWR _1898_ _2029_ _2030_ Nor_gate
XFILLER_0_9_325 VGND VGND VPWR VPWR sky130_fd_sc_hd__decap_8
XFILLER_0_15_71 VGND VGND VPWR VPWR sky130_fd_sc_hd__fill_1
XFILLER_0_17_103 VGND VGND VPWR VPWR sky130_fd_sc_hd__fill_1
XFILLER_0_40_161 VPWR VGND VPWR VGND sky130_ef_sc_hd__decap_12
X_2788_ VGND VGND VPWR VPWR net23 _1894_ _1815_ Nand_gate
XFILLER_0_32_139 VGND VGND VPWR VPWR sky130_fd_sc_hd__fill_1
X_3409_ VGND VGND VPWR VPWR _0363_ _0366_ _0367_ Nor_gate
XFILLER_0_48_261 VGND VGND VPWR VPWR sky130_fd_sc_hd__decap_3
XFILLER_0_48_250 VGND VGND VPWR VPWR sky130_fd_sc_hd__fill_2
XFILLER_0_54_253 VPWR VGND VPWR VGND sky130_ef_sc_hd__decap_12
XFILLER_0_52_58 VGND VGND VPWR VPWR sky130_fd_sc_hd__decap_8
XFILLER_0_46_209 VGND VGND VPWR VPWR sky130_fd_sc_hd__fill_2
X_2711_ VGND VGND VPWR VPWR _1812_ _1818_ _1816_ Nand_gate
X_3760_ VGND VGND VPWR VPWR _1508_ _0746_ _0747_ Nor_gate
XFILLER_0_6_317 VGND VGND VPWR VPWR sky130_fd_sc_hd__fill_1
XFILLER_0_54_297 VGND VGND VPWR VPWR sky130_fd_sc_hd__decap_8
X_2642_ VGND VGND VPWR VPWR _1750_ _1748_ _1749_ _1716_ Mux
X_4312_ VGND VGND VPWR VPWR _0269_ _1342_ _1341_ Nand_gate
XFILLER_0_22_183 VGND VGND VPWR VPWR sky130_fd_sc_hd__decap_3
XFILLER_0_22_150 VPWR VGND VPWR VGND sky130_ef_sc_hd__decap_12
X_2573_ _1681_ VGND VGND VPWR VPWR _1682_ sky130_fd_sc_hd__clkbuf_4
X_3691_ VGND VGND VPWR VPWR _0562_ _0672_ _0610_ Nand_gate
X_3125_ VGND VGND VPWR VPWR _0056_ _0058_ _0059_ Nor_gate
X_4174_ VGND VGND VPWR VPWR _1193_ _1192_ inverter
X_4243_ VGND VGND VPWR VPWR _0686_ _0382_ _1268_ Nor_gate
X_3056_ VGND VGND VPWR VPWR _2158_ _1939_ _2157_ _1870_ Mux
XFILLER_0_37_209 VGND VGND VPWR VPWR sky130_fd_sc_hd__fill_1
XFILLER_0_9_111 VGND VGND VPWR VPWR sky130_fd_sc_hd__fill_1
X_2909_ VGND VGND VPWR VPWR _2014_ _2013_ inverter
X_3958_ VGND VGND VPWR VPWR _0960_ _0881_ inverter
X_3889_ VGND VGND VPWR VPWR _0870_ _0886_ _0883_ Nand_gate
XFILLER_0_9_144 VGND VGND VPWR VPWR sky130_fd_sc_hd__fill_2
XFILLER_0_20_109 VGND VGND VPWR VPWR sky130_fd_sc_hd__fill_1
XFILLER_0_13_150 VGND VGND VPWR VPWR sky130_fd_sc_hd__decap_3
XPHY_95 VGND VGND VPWR VPWR sky130_fd_sc_hd__decap_3
XPHY_84 VGND VGND VPWR VPWR sky130_fd_sc_hd__decap_3
XPHY_73 VGND VGND VPWR VPWR sky130_fd_sc_hd__decap_3
XFILLER_0_36_242 VGND VGND VPWR VPWR sky130_fd_sc_hd__decap_8
XPHY_62 VGND VGND VPWR VPWR sky130_fd_sc_hd__decap_3
XPHY_51 VGND VGND VPWR VPWR sky130_fd_sc_hd__decap_3
XPHY_40 VGND VGND VPWR VPWR sky130_fd_sc_hd__decap_3
XFILLER_0_51_212 VGND VGND VPWR VPWR sky130_fd_sc_hd__decap_6
XFILLER_0_3_309 VPWR VGND VPWR VGND sky130_ef_sc_hd__decap_12
XFILLER_0_2_27 VGND VGND VPWR VPWR sky130_fd_sc_hd__fill_1
X_3812_ VGND VGND VPWR VPWR _0800_ _0802_ _0803_ Nor_gate
X_3674_ VGND VGND VPWR VPWR _0215_ _0653_ _0652_ Nand_gate
XFILLER_0_12_83 VGND VGND VPWR VPWR sky130_fd_sc_hd__fill_1
X_3743_ VGND VGND VPWR VPWR _0370_ _0727_ _0728_ Nor_gate
X_2625_ VGND VGND VPWR VPWR _1733_ _1729_ _1732_ _1633_ Mux
X_2556_ VGND VGND VPWR VPWR _1665_ _1663_ _1664_ _1628_ Mux
Xoutput101 net101 VGND VGND VPWR VPWR zero sky130_fd_sc_hd__buf_2
X_2487_ VGND VGND VPWR VPWR _1418_ _1596_ _1595_ Nand_gate
XFILLER_0_10_131 VGND VGND VPWR VPWR sky130_fd_sc_hd__fill_1
X_4088_ VGND VGND VPWR VPWR _0676_ _1101_ _1099_ Nand_gate
X_4157_ VGND VGND VPWR VPWR _1162_ _1175_ _1174_ Nand_gate
X_4226_ VGND VGND VPWR VPWR _1248_ _1203_ _1249_ Nor_gate
XFILLER_0_10_197 VGND VGND VPWR VPWR sky130_fd_sc_hd__decap_3
X_3108_ VGND VGND VPWR VPWR _0030_ _0041_ _0039_ Nand_gate
XFILLER_0_18_253 VPWR VGND VPWR VGND sky130_ef_sc_hd__decap_12
X_3039_ VGND VGND VPWR VPWR _2137_ _2140_ _2141_ Nor_gate
XFILLER_0_33_289 VGND VGND VPWR VPWR sky130_fd_sc_hd__fill_1
XFILLER_0_5_191 VGND VGND VPWR VPWR sky130_fd_sc_hd__fill_1
XFILLER_0_33_27 VGND VGND VPWR VPWR sky130_fd_sc_hd__decap_6
Xinput14 a[21] VGND VGND VPWR VPWR net14 sky130_fd_sc_hd__clkbuf_1
Xinput25 a[31] VGND VGND VPWR VPWR net25 sky130_fd_sc_hd__clkbuf_2
Xinput36 alu_control[3] VGND VGND VPWR VPWR net36 sky130_fd_sc_hd__buf_2
XFILLER_0_24_201 VGND VGND VPWR VPWR sky130_fd_sc_hd__fill_1
Xinput47 b[19] VGND VGND VPWR VPWR net47 sky130_fd_sc_hd__buf_2
XFILLER_0_58_57 VGND VGND VPWR VPWR sky130_fd_sc_hd__fill_2
X_3390_ VGND VGND VPWR VPWR _0347_ _0346_ inverter
X_2341_ VGND VGND VPWR VPWR _1450_ _1327_ inverter
Xinput58 b[29] VGND VGND VPWR VPWR net58 sky130_fd_sc_hd__buf_2
X_2410_ VGND VGND VPWR VPWR _1518_ _1519_ net44 Nand_gate
XFILLER_0_35_9 VGND VGND VPWR VPWR sky130_fd_sc_hd__fill_1
X_4011_ VGND VGND VPWR VPWR _1018_ _1984_ _1985_ _1017_ Mux
X_2272_ VGND VGND VPWR VPWR net31 net67 _1133_ Nor_gate
XFILLER_0_47_337 VGND VGND VPWR VPWR sky130_fd_sc_hd__decap_8
XFILLER_0_47_304 VPWR VGND VPWR VGND sky130_ef_sc_hd__decap_12
XFILLER_0_23_82 VGND VGND VPWR VPWR sky130_fd_sc_hd__fill_1
XFILLER_0_30_215 VGND VGND VPWR VPWR sky130_fd_sc_hd__fill_2
X_3726_ VGND VGND VPWR VPWR _0693_ _0709_ _0710_ Nor_gate
X_3657_ VGND VGND VPWR VPWR _0635_ _1985_ _1984_ _0722_ Mux
X_2608_ _1588_ VGND VGND VPWR VPWR _1716_ sky130_fd_sc_hd__clkbuf_4
X_2539_ VGND VGND VPWR VPWR _1599_ _1648_ _1647_ Nand_gate
X_3588_ VGND VGND VPWR VPWR _0787_ _0557_ _0561_ Nor_gate
XFILLER_0_38_304 VGND VGND VPWR VPWR sky130_fd_sc_hd__decap_4
X_4209_ VGND VGND VPWR VPWR _1226_ _1231_ _1232_ Nor_gate
XFILLER_0_3_81 VPWR VGND VPWR VGND sky130_ef_sc_hd__decap_12
XFILLER_0_56_145 VGND VGND VPWR VPWR sky130_fd_sc_hd__fill_1
X_2890_ VGND VGND VPWR VPWR _1992_ _1994_ _1995_ Nor_gate
X_3511_ _0477_ VGND VGND VPWR VPWR net74 sky130_fd_sc_hd__buf_1
XFILLER_0_8_15 VPWR VGND VPWR VGND sky130_ef_sc_hd__decap_12
X_3442_ VGND VGND VPWR VPWR _0403_ _1491_ _0959_ _1667_ Mux
X_3373_ VGND VGND VPWR VPWR _0328_ _0196_ inverter
X_2324_ net37 VGND VGND VPWR VPWR _1433_ sky130_fd_sc_hd__clkbuf_4
X_2186_ VGND VGND VPWR VPWR _0159_ _0203_ _0192_ Nand_gate
X_2255_ VGND VGND VPWR VPWR _0895_ _0938_ _0949_ Nor_gate
XFILLER_0_18_60 VGND VGND VPWR VPWR sky130_fd_sc_hd__decap_8
XFILLER_0_47_167 VGND VGND VPWR VPWR sky130_fd_sc_hd__fill_1
XFILLER_0_7_220 VGND VGND VPWR VPWR sky130_fd_sc_hd__decap_4
XFILLER_0_7_231 VGND VGND VPWR VPWR sky130_fd_sc_hd__fill_1
X_3709_ VGND VGND VPWR VPWR _0689_ _0691_ _0692_ Nor_gate
XFILLER_0_14_29 VGND VGND VPWR VPWR sky130_fd_sc_hd__fill_1
XFILLER_0_26_329 VGND VGND VPWR VPWR sky130_fd_sc_hd__decap_6
XFILLER_0_39_26 VGND VGND VPWR VPWR sky130_fd_sc_hd__fill_1
XTAP_207 VGND VPWR sky130_fd_sc_hd__tapvpwrvgnd_1
XTAP_218 VGND VPWR sky130_fd_sc_hd__tapvpwrvgnd_1
XTAP_229 VGND VPWR sky130_fd_sc_hd__tapvpwrvgnd_1
X_2942_ VGND VGND VPWR VPWR _2046_ _1410_ net27 _1667_ Mux
X_3991_ VGND VGND VPWR VPWR _0996_ _0995_ inverter
X_2873_ VGND VGND VPWR VPWR _1461_ _1977_ _1978_ Nor_gate
XFILLER_0_40_332 VPWR VGND VPWR VGND sky130_ef_sc_hd__decap_12
X_3287_ VGND VGND VPWR VPWR _1713_ _0234_ _2147_ Nand_gate
XFILLER_0_31_3 VGND VGND VPWR VPWR sky130_fd_sc_hd__decap_8
XFILLER_0_29_81 VGND VGND VPWR VPWR sky130_fd_sc_hd__fill_1
X_2307_ VPWR VGND VGND VPWR net63 _1416_ net27 Xnor
X_3425_ VGND VGND VPWR VPWR _0378_ _0383_ _0384_ Nor_gate
X_3356_ VGND VGND VPWR VPWR _0290_ _0307_ _0309_ Nor_gate
X_2238_ VGND VGND VPWR VPWR _0744_ _0765_ _0755_ Nand_gate
XFILLER_0_35_159 VGND VGND VPWR VPWR sky130_fd_sc_hd__fill_1
XFILLER_0_0_71 VGND VGND VPWR VPWR sky130_fd_sc_hd__fill_2
XFILLER_0_25_17 VPWR VGND VPWR VGND sky130_ef_sc_hd__decap_12
XFILLER_0_58_218 VGND VGND VPWR VPWR sky130_fd_sc_hd__fill_2
XFILLER_0_26_104 VGND VGND VPWR VPWR sky130_fd_sc_hd__fill_2
XFILLER_0_1_237 VPWR VGND VPWR VGND sky130_ef_sc_hd__decap_12
X_4190_ VGND VGND VPWR VPWR _0269_ _1211_ _1210_ Nand_gate
X_3210_ VGND VGND VPWR VPWR _1919_ _0151_ _1683_ Nand_gate
XFILLER_0_5_27 VPWR VGND VPWR VGND sky130_ef_sc_hd__decap_12
X_3141_ VGND VGND VPWR VPWR _0076_ _0001_ _0077_ Nor_gate
X_3072_ VGND VGND VPWR VPWR _1327_ _0004_ _1984_ Nand_gate
XFILLER_0_9_315 VGND VGND VPWR VPWR sky130_fd_sc_hd__fill_1
X_2856_ VGND VGND VPWR VPWR _1421_ _1960_ _1961_ Nor_gate
XFILLER_0_31_71 VGND VGND VPWR VPWR sky130_fd_sc_hd__fill_2
X_2925_ VGND VGND VPWR VPWR _2026_ _2027_ _2029_ Nor_gate
X_3974_ VGND VGND VPWR VPWR _0921_ _0977_ _0976_ Nand_gate
XFILLER_0_15_94 VGND VGND VPWR VPWR sky130_fd_sc_hd__fill_2
XFILLER_0_40_173 VGND VGND VPWR VPWR sky130_fd_sc_hd__decap_6
X_2787_ VPWR VGND VGND VPWR _1420_ _1893_ _1892_ Xnor
XFILLER_0_0_281 VGND VGND VPWR VPWR sky130_fd_sc_hd__fill_2
X_3408_ VGND VGND VPWR VPWR _1690_ _0366_ _0364_ Nand_gate
X_3339_ VGND VGND VPWR VPWR _0156_ _0219_ _0291_ Nor_gate
XFILLER_0_11_19 VPWR VGND VPWR VGND sky130_ef_sc_hd__decap_12
XFILLER_0_36_27 VGND VGND VPWR VPWR sky130_fd_sc_hd__fill_1
XFILLER_0_31_173 VGND VGND VPWR VPWR sky130_fd_sc_hd__fill_1
XFILLER_0_52_37 VGND VGND VPWR VPWR sky130_fd_sc_hd__decap_3
XFILLER_0_52_15 VPWR VGND VPWR VGND sky130_ef_sc_hd__decap_12
XFILLER_0_54_265 VGND VGND VPWR VPWR sky130_fd_sc_hd__decap_6
XFILLER_0_39_262 VGND VGND VPWR VPWR sky130_fd_sc_hd__decap_3
X_2710_ VGND VGND VPWR VPWR _1812_ _1816_ _1817_ Nor_gate
X_3690_ VGND VGND VPWR VPWR _0659_ _0670_ _0671_ Nor_gate
X_2641_ VGND VGND VPWR VPWR _1749_ _1544_ _1570_ _1433_ Mux
X_4242_ VGND VGND VPWR VPWR _1264_ _1266_ _1267_ Nor_gate
X_4311_ VGND VGND VPWR VPWR _2147_ _1341_ _1298_ Nand_gate
X_2572_ VGND VGND VPWR VPWR _1679_ _1680_ _1681_ Nor_gate
XFILLER_0_22_162 VGND VGND VPWR VPWR sky130_fd_sc_hd__decap_6
X_3055_ VGND VGND VPWR VPWR _2157_ _2156_ inverter
X_3124_ VGND VGND VPWR VPWR _1700_ _0058_ _0057_ Nand_gate
X_4173_ VGND VGND VPWR VPWR _1188_ _1191_ _1192_ Nor_gate
XFILLER_0_45_221 VGND VGND VPWR VPWR sky130_fd_sc_hd__decap_3
XFILLER_0_26_93 VGND VGND VPWR VPWR sky130_fd_sc_hd__fill_2
X_3957_ VGND VGND VPWR VPWR net84 _0958_ inverter
X_2908_ VGND VGND VPWR VPWR _2013_ net27 _1420_ _1607_ Mux
X_2839_ VGND VGND VPWR VPWR _1944_ _1880_ _1945_ Nor_gate
X_3888_ VGND VGND VPWR VPWR _0870_ _0883_ _0885_ Nor_gate
XFILLER_0_9_178 VGND VGND VPWR VPWR sky130_fd_sc_hd__fill_1
XTAP_390 VGND VPWR sky130_fd_sc_hd__tapvpwrvgnd_1
XPHY_30 VGND VGND VPWR VPWR sky130_fd_sc_hd__decap_3
XPHY_96 VGND VGND VPWR VPWR sky130_fd_sc_hd__decap_3
XPHY_85 VGND VGND VPWR VPWR sky130_fd_sc_hd__decap_3
XPHY_74 VGND VGND VPWR VPWR sky130_fd_sc_hd__decap_3
XPHY_63 VGND VGND VPWR VPWR sky130_fd_sc_hd__decap_3
XPHY_52 VGND VGND VPWR VPWR sky130_fd_sc_hd__decap_3
XFILLER_0_22_29 VGND VGND VPWR VPWR sky130_fd_sc_hd__decap_6
XPHY_41 VGND VGND VPWR VPWR sky130_fd_sc_hd__decap_3
XFILLER_0_36_298 VGND VGND VPWR VPWR sky130_fd_sc_hd__decap_6
XFILLER_0_47_15 VPWR VGND VPWR VGND sky130_ef_sc_hd__decap_12
X_3811_ VGND VGND VPWR VPWR _0594_ _0802_ _0801_ Nand_gate
X_2624_ VGND VGND VPWR VPWR _1732_ _1730_ _1731_ _1628_ Mux
XFILLER_0_42_213 VGND VGND VPWR VPWR sky130_fd_sc_hd__fill_2
XFILLER_0_2_321 VPWR VGND VPWR VGND sky130_ef_sc_hd__decap_12
XFILLER_0_6_137 VGND VGND VPWR VPWR sky130_fd_sc_hd__decap_3
X_3673_ VGND VGND VPWR VPWR _0555_ _0652_ _0651_ Nand_gate
X_3742_ VGND VGND VPWR VPWR _0619_ _0726_ _0727_ Nor_gate
X_2555_ VGND VGND VPWR VPWR _1664_ _1546_ _1544_ _1433_ Mux
X_2486_ VGND VGND VPWR VPWR _1584_ _1594_ _1595_ Nor_gate
X_4225_ VGND VGND VPWR VPWR _1570_ _1199_ _1248_ Nor_gate
X_4087_ VGND VGND VPWR VPWR _1083_ _1099_ _1097_ Nand_gate
X_4156_ VGND VGND VPWR VPWR _1163_ _1173_ _1174_ Nor_gate
X_3107_ VGND VGND VPWR VPWR _0037_ _0038_ _0039_ Nor_gate
X_3038_ VGND VGND VPWR VPWR _2138_ _2140_ _2139_ Nand_gate
XFILLER_0_53_80 VPWR VGND VPWR VGND sky130_ef_sc_hd__decap_12
XFILLER_0_18_265 VGND VGND VPWR VPWR sky130_fd_sc_hd__fill_1
XFILLER_0_18_243 VGND VGND VPWR VPWR sky130_fd_sc_hd__decap_8
Xinput37 b[0] VGND VGND VPWR VPWR net37 sky130_fd_sc_hd__clkbuf_4
Xinput48 b[1] VGND VGND VPWR VPWR net48 sky130_fd_sc_hd__buf_1
Xinput15 a[22] VGND VGND VPWR VPWR net15 sky130_fd_sc_hd__clkbuf_2
Xinput26 a[3] VGND VGND VPWR VPWR net26 sky130_fd_sc_hd__dlymetal6s2s_1
Xinput59 b[2] VGND VGND VPWR VPWR net59 sky130_fd_sc_hd__buf_1
XFILLER_0_24_213 VGND VGND VPWR VPWR sky130_fd_sc_hd__fill_2
XFILLER_0_3_118 VGND VGND VPWR VPWR sky130_fd_sc_hd__fill_2
X_2271_ VGND VGND VPWR VPWR _1089_ _1111_ _1122_ Nor_gate
X_2340_ VGND VGND VPWR VPWR _1316_ _1348_ _1449_ Nor_gate
X_4010_ VGND VGND VPWR VPWR _1662_ _1550_ _1017_ Nor_gate
XFILLER_0_47_316 VPWR VGND VPWR VGND sky130_ef_sc_hd__decap_12
X_2607_ VGND VGND VPWR VPWR _1715_ _1316_ net31 _1610_ Mux
XFILLER_0_30_238 VGND VGND VPWR VPWR sky130_fd_sc_hd__fill_2
X_3725_ VGND VGND VPWR VPWR _0702_ _0709_ _0708_ Nand_gate
X_3587_ VGND VGND VPWR VPWR _0559_ _0558_ inverter
X_3656_ VGND VGND VPWR VPWR _0634_ _0633_ inverter
X_2538_ VGND VGND VPWR VPWR _1645_ _1646_ _1647_ Nor_gate
X_4208_ VGND VGND VPWR VPWR _1682_ _1229_ _1231_ Nor_gate
X_2469_ VGND VGND VPWR VPWR _1558_ _1578_ _1577_ Nand_gate
XFILLER_0_2_195 VGND VGND VPWR VPWR sky130_fd_sc_hd__fill_1
X_4139_ VGND VGND VPWR VPWR _1156_ _0941_ _1155_ _0379_ Mux
XFILLER_0_38_338 VGND VGND VPWR VPWR sky130_fd_sc_hd__decap_8
XFILLER_0_3_93 VPWR VGND VPWR VGND sky130_ef_sc_hd__decap_12
XFILLER_0_44_27 VGND VGND VPWR VPWR sky130_fd_sc_hd__fill_1
XFILLER_0_56_135 VGND VGND VPWR VPWR sky130_fd_sc_hd__fill_2
X_3441_ VGND VGND VPWR VPWR _0402_ _0137_ inverter
X_3510_ VGND VGND VPWR VPWR _0436_ _0477_ _0476_ Nand_gate
XFILLER_0_8_27 VGND VGND VPWR VPWR sky130_fd_sc_hd__fill_1
XFILLER_0_12_227 VGND VGND VPWR VPWR sky130_fd_sc_hd__fill_1
X_2323_ _1431_ VGND VGND VPWR VPWR _1432_ sky130_fd_sc_hd__clkbuf_4
X_3372_ VGND VGND VPWR VPWR _0321_ _0327_ _0326_ Nand_gate
X_2254_ VGND VGND VPWR VPWR _0906_ _0927_ _0938_ Nor_gate
XFILLER_0_47_113 VGND VGND VPWR VPWR sky130_fd_sc_hd__decap_3
X_2185_ VGND VGND VPWR VPWR _0170_ _0192_ _0181_ Nand_gate
XFILLER_0_18_83 VGND VGND VPWR VPWR sky130_fd_sc_hd__fill_1
XFILLER_0_55_190 VGND VGND VPWR VPWR sky130_fd_sc_hd__decap_6
XFILLER_0_47_124 VGND VGND VPWR VPWR sky130_fd_sc_hd__decap_6
XFILLER_0_34_93 VGND VGND VPWR VPWR sky130_fd_sc_hd__decap_3
XFILLER_0_7_210 VGND VGND VPWR VPWR sky130_fd_sc_hd__fill_1
XFILLER_0_7_254 VPWR VGND VPWR VGND sky130_ef_sc_hd__decap_12
X_3708_ VGND VGND VPWR VPWR _1648_ _1856_ _0691_ Nor_gate
X_3639_ VGND VGND VPWR VPWR _0612_ _0616_ _0615_ Nand_gate
XFILLER_0_38_135 VGND VGND VPWR VPWR sky130_fd_sc_hd__fill_2
XFILLER_0_53_138 VGND VGND VPWR VPWR sky130_fd_sc_hd__decap_6
XFILLER_0_30_29 VGND VGND VPWR VPWR sky130_fd_sc_hd__decap_4
XTAP_208 VGND VPWR sky130_fd_sc_hd__tapvpwrvgnd_1
XTAP_219 VGND VPWR sky130_fd_sc_hd__tapvpwrvgnd_1
X_3990_ VGND VGND VPWR VPWR _1863_ _0055_ _0995_ Nor_gate
XFILLER_0_29_102 VGND VGND VPWR VPWR sky130_fd_sc_hd__decap_6
XFILLER_0_44_105 VGND VGND VPWR VPWR sky130_fd_sc_hd__decap_4
X_2941_ VGND VGND VPWR VPWR _1624_ _1861_ _2045_ Nor_gate
X_2872_ VGND VGND VPWR VPWR net23 _1977_ net26 Nand_gate
XFILLER_0_4_224 VGND VGND VPWR VPWR sky130_fd_sc_hd__decap_6
X_3424_ VGND VGND VPWR VPWR _2000_ _0382_ _0383_ Nor_gate
X_3286_ VGND VGND VPWR VPWR _0233_ _1903_ inverter
X_2306_ VGND VGND VPWR VPWR _1413_ _1415_ _1414_ Nand_gate
XFILLER_0_24_3 VGND VGND VPWR VPWR sky130_fd_sc_hd__decap_6
X_3355_ VGND VGND VPWR VPWR _0290_ _0308_ _0307_ Nand_gate
X_2237_ VGND VGND VPWR VPWR _0755_ net45 inverter
XFILLER_0_45_70 VGND VGND VPWR VPWR sky130_fd_sc_hd__decap_4
XFILLER_0_0_83 VGND VGND VPWR VPWR sky130_fd_sc_hd__fill_1
XFILLER_0_35_138 VGND VGND VPWR VPWR sky130_fd_sc_hd__decap_3
XFILLER_0_31_322 VGND VGND VPWR VPWR sky130_fd_sc_hd__fill_1
XFILLER_0_31_300 VGND VGND VPWR VPWR sky130_fd_sc_hd__decap_4
XFILLER_0_25_29 VGND VGND VPWR VPWR sky130_fd_sc_hd__fill_1
XFILLER_0_26_149 VPWR VGND VPWR VGND sky130_ef_sc_hd__decap_12
XFILLER_0_34_160 VGND VGND VPWR VPWR sky130_fd_sc_hd__decap_3
XFILLER_0_1_249 VPWR VGND VPWR VGND sky130_ef_sc_hd__decap_12
XFILLER_0_1_205 VPWR VGND VPWR VGND sky130_ef_sc_hd__decap_12
X_3071_ VGND VGND VPWR VPWR _1327_ _1684_ _0003_ Nor_gate
XFILLER_0_5_39 VPWR VGND VPWR VGND sky130_ef_sc_hd__decap_12
X_3140_ VGND VGND VPWR VPWR _0076_ net67 inverter
X_3973_ VGND VGND VPWR VPWR net52 _0976_ _0215_ Nand_gate
XFILLER_0_15_51 VGND VGND VPWR VPWR sky130_fd_sc_hd__decap_4
X_2855_ VGND VGND VPWR VPWR _1960_ _1892_ inverter
X_2786_ VPWR VGND VGND VPWR net62 _1892_ _1891_ Xnor
XFILLER_0_32_108 VGND VGND VPWR VPWR sky130_fd_sc_hd__decap_4
XFILLER_0_31_94 VGND VGND VPWR VPWR sky130_fd_sc_hd__fill_1
X_2924_ VGND VGND VPWR VPWR _2026_ _2028_ _2027_ Nand_gate
XFILLER_0_13_333 VGND VGND VPWR VPWR sky130_fd_sc_hd__decap_3
XFILLER_0_17_138 VGND VGND VPWR VPWR sky130_fd_sc_hd__decap_8
X_3338_ VGND VGND VPWR VPWR _0287_ _0288_ _0290_ Nor_gate
X_3407_ VGND VGND VPWR VPWR _0361_ _0364_ _0362_ Nand_gate
X_3269_ _0151_ VGND VGND VPWR VPWR _0215_ sky130_fd_sc_hd__clkbuf_4
XFILLER_0_31_130 VGND VGND VPWR VPWR sky130_fd_sc_hd__decap_6
XFILLER_0_23_108 VGND VGND VPWR VPWR sky130_fd_sc_hd__decap_4
XFILLER_0_16_193 VGND VGND VPWR VPWR sky130_fd_sc_hd__decap_3
XFILLER_0_52_27 VGND VGND VPWR VPWR sky130_fd_sc_hd__fill_1
X_2640_ VGND VGND VPWR VPWR _1748_ _1548_ _1546_ _1433_ Mux
XFILLER_0_39_274 VGND VGND VPWR VPWR sky130_fd_sc_hd__decap_6
XFILLER_0_58_9 VGND VGND VPWR VPWR sky130_fd_sc_hd__decap_3
X_4241_ VGND VGND VPWR VPWR _0594_ _1266_ _1265_ Nand_gate
X_4310_ VGND VGND VPWR VPWR _2147_ _1298_ _1340_ Nor_gate
X_2571_ VGND VGND VPWR VPWR _1645_ _1680_ _1599_ Nand_gate
XFILLER_0_22_141 VGND VGND VPWR VPWR sky130_fd_sc_hd__fill_2
X_3054_ VGND VGND VPWR VPWR _2156_ _2046_ _2154_ _2155_ Mux
X_3123_ VGND VGND VPWR VPWR _1726_ _0057_ _1634_ Nand_gate
X_4172_ VGND VGND VPWR VPWR _1139_ _1190_ _1191_ Nor_gate
XFILLER_0_26_61 VGND VGND VPWR VPWR sky130_fd_sc_hd__fill_1
X_2907_ VGND VGND VPWR VPWR _2012_ _1864_ inverter
XFILLER_0_42_93 VGND VGND VPWR VPWR sky130_fd_sc_hd__fill_1
X_3956_ VGND VGND VPWR VPWR _0931_ _0957_ _0958_ Nor_gate
XFILLER_0_9_113 VGND VGND VPWR VPWR sky130_fd_sc_hd__decap_4
XFILLER_0_45_299 VPWR VGND VPWR VGND sky130_ef_sc_hd__decap_12
XFILLER_0_45_277 VGND VGND VPWR VPWR sky130_fd_sc_hd__decap_3
X_2769_ VGND VGND VPWR VPWR _1875_ _1684_ _1876_ Nor_gate
X_2838_ VGND VGND VPWR VPWR _1624_ _1420_ _1944_ Nor_gate
X_3887_ VGND VGND VPWR VPWR _0872_ _0882_ _0883_ Nor_gate
XTAP_391 VGND VPWR sky130_fd_sc_hd__tapvpwrvgnd_1
XTAP_380 VGND VPWR sky130_fd_sc_hd__tapvpwrvgnd_1
XPHY_64 VGND VGND VPWR VPWR sky130_fd_sc_hd__decap_3
XPHY_53 VGND VGND VPWR VPWR sky130_fd_sc_hd__decap_3
XPHY_42 VGND VGND VPWR VPWR sky130_fd_sc_hd__decap_3
XPHY_20 VGND VGND VPWR VPWR sky130_fd_sc_hd__decap_3
XPHY_31 VGND VGND VPWR VPWR sky130_fd_sc_hd__decap_3
XFILLER_0_51_225 VGND VGND VPWR VPWR sky130_fd_sc_hd__decap_4
XFILLER_0_51_203 VGND VGND VPWR VPWR sky130_fd_sc_hd__decap_3
XPHY_97 VGND VGND VPWR VPWR sky130_fd_sc_hd__decap_3
XPHY_86 VGND VGND VPWR VPWR sky130_fd_sc_hd__decap_3
XPHY_75 VGND VGND VPWR VPWR sky130_fd_sc_hd__decap_3
XFILLER_0_36_200 VGND VGND VPWR VPWR sky130_fd_sc_hd__decap_4
XFILLER_0_47_27 VPWR VGND VPWR VGND sky130_ef_sc_hd__decap_12
XFILLER_0_2_29 VPWR VGND VPWR VGND sky130_ef_sc_hd__decap_12
X_3810_ VGND VGND VPWR VPWR _0102_ _0801_ _0332_ Nand_gate
XFILLER_0_27_222 VGND VGND VPWR VPWR sky130_fd_sc_hd__fill_2
X_3741_ VGND VGND VPWR VPWR _0679_ _0726_ _0582_ Nand_gate
X_2623_ VGND VGND VPWR VPWR _1731_ net7 _0787_ _1615_ Mux
X_2554_ VGND VGND VPWR VPWR _1663_ _1662_ _1548_ _1433_ Mux
XFILLER_0_2_333 VGND VGND VPWR VPWR sky130_fd_sc_hd__decap_8
X_3672_ VGND VGND VPWR VPWR net45 net44 _0651_ Nor_gate
XFILLER_0_12_41 VGND VGND VPWR VPWR sky130_fd_sc_hd__decap_8
XFILLER_0_12_63 VPWR VGND VPWR VGND sky130_ef_sc_hd__decap_12
XFILLER_0_12_85 VPWR VGND VPWR VGND sky130_ef_sc_hd__decap_12
X_4155_ VGND VGND VPWR VPWR _1164_ _1173_ _1172_ Nand_gate
X_2485_ VGND VGND VPWR VPWR _1587_ _1594_ _1593_ Nand_gate
X_4224_ VGND VGND VPWR VPWR _1245_ _1247_ _1246_ Nand_gate
XFILLER_0_53_70 VGND VGND VPWR VPWR sky130_fd_sc_hd__fill_1
X_4086_ VGND VGND VPWR VPWR _1083_ _1097_ _1098_ Nor_gate
X_3106_ VGND VGND VPWR VPWR net31 _0035_ _0038_ Nor_gate
X_3037_ VGND VGND VPWR VPWR _2139_ _2089_ inverter
X_3939_ VGND VGND VPWR VPWR _0940_ net16 _0333_ _1676_ Mux
XFILLER_0_53_92 VGND VGND VPWR VPWR sky130_fd_sc_hd__decap_3
XFILLER_0_33_225 VGND VGND VPWR VPWR sky130_fd_sc_hd__fill_2
XFILLER_0_5_160 VGND VGND VPWR VPWR sky130_fd_sc_hd__decap_8
Xinput27 a[4] VGND VGND VPWR VPWR net27 sky130_fd_sc_hd__clkbuf_4
Xinput16 a[23] VGND VGND VPWR VPWR net16 sky130_fd_sc_hd__clkbuf_4
Xinput49 b[20] VGND VGND VPWR VPWR net49 sky130_fd_sc_hd__buf_2
Xinput38 b[10] VGND VGND VPWR VPWR net38 sky130_fd_sc_hd__clkbuf_2
X_2270_ VGND VGND VPWR VPWR _1111_ _1100_ inverter
XFILLER_0_47_328 VGND VGND VPWR VPWR sky130_fd_sc_hd__decap_8
X_3724_ VGND VGND VPWR VPWR _0705_ _0707_ _0708_ Nor_gate
X_2606_ VGND VGND VPWR VPWR _1714_ _1410_ net29 _1610_ Mux
XFILLER_0_30_206 VGND VGND VPWR VPWR sky130_fd_sc_hd__decap_3
X_3655_ VGND VGND VPWR VPWR _0228_ _0632_ _0633_ Nor_gate
X_2537_ VGND VGND VPWR VPWR net34 _1646_ net33 Nand_gate
XFILLER_0_2_174 VGND VGND VPWR VPWR sky130_fd_sc_hd__fill_1
XFILLER_0_2_141 VGND VGND VPWR VPWR sky130_fd_sc_hd__fill_2
X_3586_ VGND VGND VPWR VPWR _0787_ _0558_ _0557_ Nand_gate
XFILLER_0_54_3 VPWR VGND VPWR VGND sky130_ef_sc_hd__decap_12
X_4138_ VGND VGND VPWR VPWR _1155_ _1052_ _1153_ _0255_ Mux
X_4207_ VGND VGND VPWR VPWR _1229_ _1984_ _1985_ _1228_ Mux
X_2468_ VGND VGND VPWR VPWR _1559_ _1576_ _1577_ Nor_gate
X_2399_ VGND VGND VPWR VPWR _0582_ net47 _1508_ Nor_gate
X_4069_ VGND VGND VPWR VPWR _0355_ _1079_ _1080_ Nor_gate
XFILLER_0_21_239 VGND VGND VPWR VPWR sky130_fd_sc_hd__fill_2
XFILLER_0_44_309 VPWR VGND VPWR VGND sky130_ef_sc_hd__decap_12
X_3440_ VGND VGND VPWR VPWR _0401_ _2048_ inverter
X_3371_ VGND VGND VPWR VPWR _0326_ _0325_ inverter
X_2322_ VGND VGND VPWR VPWR _1431_ net48 inverter
X_2184_ VGND VGND VPWR VPWR _0181_ net58 inverter
X_2253_ VGND VGND VPWR VPWR _0927_ _0917_ inverter
XFILLER_0_47_169 VPWR VGND VPWR VGND sky130_ef_sc_hd__decap_12
X_3707_ VGND VGND VPWR VPWR _0113_ _0688_ _0689_ Nor_gate
XFILLER_0_7_200 VGND VGND VPWR VPWR sky130_fd_sc_hd__fill_2
XFILLER_0_7_266 VGND VGND VPWR VPWR sky130_fd_sc_hd__fill_1
X_3638_ VGND VGND VPWR VPWR _0042_ _0613_ _0615_ Nor_gate
X_3569_ VGND VGND VPWR VPWR _0536_ _0540_ _0539_ Nand_gate
XFILLER_0_53_128 VGND VGND VPWR VPWR sky130_fd_sc_hd__fill_1
XFILLER_0_38_147 VGND VGND VPWR VPWR sky130_fd_sc_hd__decap_6
XFILLER_0_38_103 VPWR VGND VPWR VGND sky130_ef_sc_hd__decap_12
XFILLER_0_26_309 VPWR VGND VPWR VGND sky130_ef_sc_hd__decap_12
XTAP_209 VGND VPWR sky130_fd_sc_hd__tapvpwrvgnd_1
X_2940_ VGND VGND VPWR VPWR _2000_ _2043_ _2044_ Nor_gate
XFILLER_0_44_139 VGND VGND VPWR VPWR sky130_fd_sc_hd__fill_1
XFILLER_0_40_301 VGND VGND VPWR VPWR sky130_fd_sc_hd__fill_1
XFILLER_0_37_180 VGND VGND VPWR VPWR sky130_fd_sc_hd__decap_4
X_2871_ VGND VGND VPWR VPWR _1973_ _1975_ _1976_ Nor_gate
XFILLER_0_29_169 VGND VGND VPWR VPWR sky130_fd_sc_hd__fill_2
XFILLER_0_29_158 VGND VGND VPWR VPWR sky130_fd_sc_hd__fill_1
XFILLER_0_20_41 VGND VGND VPWR VPWR sky130_fd_sc_hd__fill_1
XFILLER_0_4_236 VGND VGND VPWR VPWR sky130_fd_sc_hd__fill_1
X_3423_ VGND VGND VPWR VPWR _0345_ _0381_ _0382_ Nor_gate
X_3354_ VGND VGND VPWR VPWR _0294_ _0307_ _0306_ Nand_gate
X_3285_ VGND VGND VPWR VPWR _0227_ _0232_ _0231_ Nand_gate
X_2305_ VGND VGND VPWR VPWR net28 _1414_ net64 Nand_gate
X_2236_ VGND VGND VPWR VPWR _0744_ _0733_ inverter
XFILLER_0_0_51 VGND VGND VPWR VPWR sky130_fd_sc_hd__decap_4
XFILLER_0_43_172 VGND VGND VPWR VPWR sky130_fd_sc_hd__decap_6
XFILLER_0_43_150 VPWR VGND VPWR VGND sky130_ef_sc_hd__decap_12
XFILLER_0_31_345 VGND VGND VPWR VPWR sky130_fd_sc_hd__fill_2
XFILLER_0_28_191 VGND VGND VPWR VPWR sky130_fd_sc_hd__decap_4
XFILLER_0_9_82 VGND VGND VPWR VPWR sky130_fd_sc_hd__fill_2
XFILLER_0_16_342 VGND VGND VPWR VPWR sky130_fd_sc_hd__fill_1
XFILLER_0_41_18 VPWR VGND VPWR VGND sky130_ef_sc_hd__decap_12
XFILLER_0_26_139 VGND VGND VPWR VPWR sky130_fd_sc_hd__fill_1
XFILLER_0_34_183 VGND VGND VPWR VPWR sky130_fd_sc_hd__decap_4
XFILLER_0_34_172 VGND VGND VPWR VPWR sky130_fd_sc_hd__decap_4
XFILLER_0_22_345 VGND VGND VPWR VPWR sky130_fd_sc_hd__fill_2
XFILLER_0_1_217 VGND VGND VPWR VPWR sky130_fd_sc_hd__decap_6
X_3070_ VGND VGND VPWR VPWR _1348_ _0001_ _0002_ Nor_gate
XFILLER_0_49_209 VGND VGND VPWR VPWR sky130_fd_sc_hd__fill_1
X_2923_ VGND VGND VPWR VPWR _1969_ _2027_ _1974_ Nand_gate
X_3972_ VGND VGND VPWR VPWR _0964_ _0975_ _0974_ Nand_gate
XFILLER_0_40_153 VGND VGND VPWR VPWR sky130_fd_sc_hd__fill_2
X_2854_ VGND VGND VPWR VPWR _1420_ _1892_ _1959_ Nor_gate
X_2785_ VGND VGND VPWR VPWR _1813_ _1890_ _1891_ Nor_gate
XFILLER_0_25_172 VGND VGND VPWR VPWR sky130_fd_sc_hd__decap_4
XFILLER_0_13_345 VGND VGND VPWR VPWR sky130_fd_sc_hd__fill_2
XFILLER_0_0_261 VGND VGND VPWR VPWR sky130_fd_sc_hd__decap_8
X_3337_ VGND VGND VPWR VPWR _0959_ _0285_ _0288_ Nor_gate
X_3406_ VGND VGND VPWR VPWR _0361_ _0362_ _0363_ Nor_gate
X_3199_ VGND VGND VPWR VPWR _0135_ _0140_ _0139_ Nand_gate
X_3268_ _0213_ VGND VGND VPWR VPWR net70 sky130_fd_sc_hd__clkbuf_2
X_2219_ VGND VGND VPWR VPWR _0441_ _0560_ _0549_ Nand_gate
XFILLER_0_48_253 VGND VGND VPWR VPWR sky130_fd_sc_hd__decap_8
XFILLER_0_48_231 VGND VGND VPWR VPWR sky130_fd_sc_hd__fill_1
XFILLER_0_31_186 VGND VGND VPWR VPWR sky130_fd_sc_hd__decap_8
XFILLER_0_54_289 VGND VGND VPWR VPWR sky130_fd_sc_hd__fill_2
X_2570_ VGND VGND VPWR VPWR _1678_ _1679_ net33 Nand_gate
XFILLER_0_6_309 VGND VGND VPWR VPWR sky130_fd_sc_hd__decap_4
X_3122_ VGND VGND VPWR VPWR _1726_ _1661_ _0056_ Nor_gate
X_4171_ VGND VGND VPWR VPWR _1190_ _1189_ inverter
X_4240_ VGND VGND VPWR VPWR _0686_ _1265_ _0407_ Nand_gate
XFILLER_0_22_197 VGND VGND VPWR VPWR sky130_fd_sc_hd__decap_8
X_3053_ _1938_ VGND VGND VPWR VPWR _2155_ sky130_fd_sc_hd__clkbuf_4
X_2906_ VGND VGND VPWR VPWR _1424_ _2011_ _1702_ Nand_gate
X_3955_ VGND VGND VPWR VPWR _0936_ _0957_ _0956_ Nand_gate
X_3886_ VGND VGND VPWR VPWR _0880_ _0881_ _0882_ Nor_gate
XFILLER_0_9_103 VGND VGND VPWR VPWR sky130_fd_sc_hd__decap_8
X_2768_ VGND VGND VPWR VPWR _1713_ _1875_ _1428_ Nand_gate
X_2837_ VGND VGND VPWR VPWR _1426_ _1873_ _1943_ Nor_gate
X_2699_ VGND VGND VPWR VPWR _1784_ _1806_ _1807_ Nor_gate
XFILLER_0_13_197 VGND VGND VPWR VPWR sky130_fd_sc_hd__decap_3
XTAP_392 VGND VPWR sky130_fd_sc_hd__tapvpwrvgnd_1
XTAP_381 VGND VPWR sky130_fd_sc_hd__tapvpwrvgnd_1
XTAP_370 VGND VPWR sky130_fd_sc_hd__tapvpwrvgnd_1
X_4369_ VGND VGND VPWR VPWR _1399_ _1403_ _1404_ Nor_gate
XFILLER_0_6_83 VGND VGND VPWR VPWR sky130_fd_sc_hd__fill_1
XPHY_98 VGND VGND VPWR VPWR sky130_fd_sc_hd__decap_3
XPHY_87 VGND VGND VPWR VPWR sky130_fd_sc_hd__decap_3
XPHY_76 VGND VGND VPWR VPWR sky130_fd_sc_hd__decap_3
XPHY_65 VGND VGND VPWR VPWR sky130_fd_sc_hd__decap_3
XPHY_54 VGND VGND VPWR VPWR sky130_fd_sc_hd__decap_3
XPHY_43 VGND VGND VPWR VPWR sky130_fd_sc_hd__decap_3
XPHY_10 VGND VGND VPWR VPWR sky130_fd_sc_hd__decap_3
XPHY_21 VGND VGND VPWR VPWR sky130_fd_sc_hd__decap_3
XPHY_32 VGND VGND VPWR VPWR sky130_fd_sc_hd__decap_3
XFILLER_0_47_39 VGND VGND VPWR VPWR sky130_fd_sc_hd__decap_4
XFILLER_0_27_256 VGND VGND VPWR VPWR sky130_fd_sc_hd__fill_1
X_3740_ VGND VGND VPWR VPWR _0603_ _0725_ _0682_ Nand_gate
X_2622_ VGND VGND VPWR VPWR _1730_ net5 net6 _1610_ Mux
X_2553_ VGND VGND VPWR VPWR _1662_ net17 inverter
XFILLER_0_12_75 VGND VGND VPWR VPWR sky130_fd_sc_hd__decap_8
XFILLER_0_12_97 VPWR VGND VPWR VGND sky130_ef_sc_hd__decap_12
X_3671_ _0650_ VGND VGND VPWR VPWR net77 sky130_fd_sc_hd__dlymetal6s2s_1
X_4154_ VGND VGND VPWR VPWR _1172_ _1171_ inverter
X_2484_ VGND VGND VPWR VPWR _1591_ _1593_ _1592_ Nand_gate
X_4085_ VGND VGND VPWR VPWR _1085_ _1096_ _1097_ Nor_gate
X_4223_ VGND VGND VPWR VPWR _1565_ _1246_ _1243_ Nand_gate
X_3105_ VGND VGND VPWR VPWR _0037_ _0036_ inverter
XFILLER_0_10_189 VGND VGND VPWR VPWR sky130_fd_sc_hd__decap_6
X_3036_ VGND VGND VPWR VPWR net29 _2138_ _2073_ Nand_gate
X_3869_ VGND VGND VPWR VPWR net82 _0864_ inverter
X_3938_ VGND VGND VPWR VPWR _0229_ _0939_ _0504_ Nand_gate
XFILLER_0_41_281 VPWR VGND VPWR VGND sky130_ef_sc_hd__decap_12
XFILLER_0_56_307 VGND VGND VPWR VPWR sky130_fd_sc_hd__fill_1
Xinput28 a[5] VGND VGND VPWR VPWR net28 sky130_fd_sc_hd__clkbuf_2
Xinput17 a[24] VGND VGND VPWR VPWR net17 sky130_fd_sc_hd__buf_2
XFILLER_0_32_281 VGND VGND VPWR VPWR sky130_fd_sc_hd__decap_8
Xinput39 b[11] VGND VGND VPWR VPWR net39 sky130_fd_sc_hd__clkbuf_2
X_3654_ VGND VGND VPWR VPWR _0624_ _0631_ _0632_ Nor_gate
XFILLER_0_23_96 VGND VGND VPWR VPWR sky130_fd_sc_hd__decap_6
X_3723_ VGND VGND VPWR VPWR _0642_ _0707_ _0706_ Nand_gate
XFILLER_0_15_259 VGND VGND VPWR VPWR sky130_fd_sc_hd__fill_1
X_2605_ _1712_ VGND VGND VPWR VPWR _1713_ sky130_fd_sc_hd__clkbuf_4
XFILLER_0_23_281 VPWR VGND VPWR VGND sky130_ef_sc_hd__decap_12
X_2536_ VGND VGND VPWR VPWR _1645_ net35 inverter
X_2467_ VGND VGND VPWR VPWR _1560_ _1575_ _1576_ Nor_gate
XFILLER_0_2_197 VPWR VGND VPWR VGND sky130_ef_sc_hd__decap_12
XFILLER_0_2_186 VGND VGND VPWR VPWR sky130_fd_sc_hd__decap_6
XFILLER_0_2_164 VGND VGND VPWR VPWR sky130_fd_sc_hd__decap_4
X_3585_ VPWR VGND VGND VPWR net44 _0557_ _0556_ Xnor
X_4137_ VGND VGND VPWR VPWR _1153_ net20 net19 _1676_ Mux
XFILLER_0_47_3 VPWR VGND VPWR VGND sky130_ef_sc_hd__decap_12
X_4068_ VGND VGND VPWR VPWR net54 net53 _1079_ Nor_gate
X_4206_ VGND VGND VPWR VPWR _1570_ _1227_ _1228_ Nor_gate
XFILLER_0_3_51 VGND VGND VPWR VPWR sky130_fd_sc_hd__decap_4
X_2398_ VGND VGND VPWR VPWR _1507_ _0593_ inverter
X_3019_ VGND VGND VPWR VPWR _1681_ _2121_ _2122_ Nor_gate
XFILLER_0_14_281 VGND VGND VPWR VPWR sky130_fd_sc_hd__fill_1
XFILLER_0_44_29 VPWR VGND VPWR VGND sky130_ef_sc_hd__decap_12
XFILLER_0_29_318 VGND VGND VPWR VPWR sky130_fd_sc_hd__decap_8
XFILLER_0_56_159 VGND VGND VPWR VPWR sky130_fd_sc_hd__fill_2
XFILLER_0_52_321 VPWR VGND VPWR VGND sky130_ef_sc_hd__decap_12
XFILLER_0_8_29 VPWR VGND VPWR VGND sky130_ef_sc_hd__decap_12
X_2321_ VGND VGND VPWR VPWR _1430_ net12 inverter
X_3370_ VGND VGND VPWR VPWR _0970_ _0324_ _0325_ Nor_gate
XFILLER_0_12_207 VPWR VGND VPWR VGND sky130_ef_sc_hd__decap_12
X_2183_ VGND VGND VPWR VPWR _0170_ net22 inverter
X_2252_ VGND VGND VPWR VPWR net5 _0917_ net41 Nand_gate
XFILLER_0_18_85 VPWR VGND VPWR VGND sky130_ef_sc_hd__decap_12
XFILLER_0_50_83 VGND VGND VPWR VPWR sky130_fd_sc_hd__fill_1
X_3706_ VGND VGND VPWR VPWR _1837_ _0687_ _0688_ Nor_gate
X_3637_ VGND VGND VPWR VPWR _0610_ _0611_ _0613_ Nor_gate
XFILLER_0_7_278 VGND VGND VPWR VPWR sky130_fd_sc_hd__fill_2
X_2519_ _1588_ VGND VGND VPWR VPWR _1628_ sky130_fd_sc_hd__clkbuf_4
X_3499_ VGND VGND VPWR VPWR _1625_ _0464_ _0465_ Nor_gate
X_3568_ VGND VGND VPWR VPWR _0421_ _0537_ _0539_ Nor_gate
XFILLER_0_11_284 VPWR VGND VPWR VGND sky130_ef_sc_hd__decap_12
XFILLER_0_46_192 VGND VGND VPWR VPWR sky130_fd_sc_hd__decap_4
XFILLER_0_46_181 VGND VGND VPWR VPWR sky130_fd_sc_hd__fill_2
XFILLER_0_38_115 VPWR VGND VPWR VGND sky130_ef_sc_hd__decap_12
XFILLER_0_34_321 VGND VGND VPWR VPWR sky130_fd_sc_hd__fill_2
X_2870_ VGND VGND VPWR VPWR _1690_ _1975_ _1974_ Nand_gate
XFILLER_0_52_195 VGND VGND VPWR VPWR sky130_fd_sc_hd__fill_1
XFILLER_0_52_184 VGND VGND VPWR VPWR sky130_fd_sc_hd__decap_4
XFILLER_0_25_332 VGND VGND VPWR VPWR sky130_fd_sc_hd__fill_1
XFILLER_0_25_310 VGND VGND VPWR VPWR sky130_fd_sc_hd__decap_3
XFILLER_0_4_259 VGND VGND VPWR VPWR sky130_fd_sc_hd__decap_4
X_3422_ VGND VGND VPWR VPWR _0102_ _0380_ _0381_ Nor_gate
X_3284_ VGND VGND VPWR VPWR _0228_ _0230_ _0231_ Nor_gate
XFILLER_0_29_95 VGND VGND VPWR VPWR sky130_fd_sc_hd__decap_4
XFILLER_0_29_73 VGND VGND VPWR VPWR sky130_fd_sc_hd__decap_8
X_2304_ VGND VGND VPWR VPWR _1411_ _1413_ _1412_ Nand_gate
X_3353_ VGND VGND VPWR VPWR _0299_ _0305_ _0306_ Nor_gate
X_2235_ net9 VGND VGND VPWR VPWR _0733_ sky130_fd_sc_hd__clkbuf_4
X_2999_ VGND VGND VPWR VPWR _2102_ _2101_ inverter
XFILLER_0_0_63 VGND VGND VPWR VPWR sky130_fd_sc_hd__decap_8
XFILLER_0_0_85 VGND VGND VPWR VPWR sky130_fd_sc_hd__fill_2
XFILLER_0_43_184 VPWR VGND VPWR VGND sky130_ef_sc_hd__decap_12
XFILLER_0_43_162 VGND VGND VPWR VPWR sky130_fd_sc_hd__decap_3
XFILLER_0_43_140 VGND VGND VPWR VPWR sky130_fd_sc_hd__fill_1
XFILLER_0_31_335 VGND VGND VPWR VPWR sky130_fd_sc_hd__fill_1
XFILLER_0_26_129 VGND VGND VPWR VPWR sky130_fd_sc_hd__fill_1
XFILLER_0_22_324 VGND VGND VPWR VPWR sky130_fd_sc_hd__decap_3
XFILLER_0_19_181 VGND VGND VPWR VPWR sky130_fd_sc_hd__decap_3
X_2853_ VGND VGND VPWR VPWR _1956_ _1958_ _1957_ Nand_gate
X_2922_ VPWR VGND VGND VPWR _1410_ _2026_ _2025_ Xnor
X_3971_ VGND VGND VPWR VPWR _0965_ _0973_ _0974_ Nor_gate
XFILLER_0_15_75 VGND VGND VPWR VPWR sky130_fd_sc_hd__decap_6
XFILLER_0_17_107 VGND VGND VPWR VPWR sky130_fd_sc_hd__fill_2
X_2784_ VGND VGND VPWR VPWR _1438_ _1889_ _1890_ Nor_gate
XFILLER_0_25_162 VGND VGND VPWR VPWR sky130_fd_sc_hd__fill_2
XFILLER_0_56_93 VGND VGND VPWR VPWR sky130_fd_sc_hd__fill_1
X_3267_ VGND VGND VPWR VPWR _0173_ _0213_ _0212_ Nand_gate
XFILLER_0_0_273 VGND VGND VPWR VPWR sky130_fd_sc_hd__decap_6
XFILLER_0_0_251 VGND VGND VPWR VPWR sky130_fd_sc_hd__fill_1
X_3336_ VGND VGND VPWR VPWR _0287_ _0286_ inverter
X_3405_ VGND VGND VPWR VPWR _0286_ _0362_ _0308_ Nand_gate
X_3198_ VGND VGND VPWR VPWR _0139_ _2047_ _0137_ _1606_ Mux
XFILLER_0_48_243 VGND VGND VPWR VPWR sky130_fd_sc_hd__fill_1
X_2218_ VGND VGND VPWR VPWR _0495_ _0538_ _0549_ Nor_gate
XFILLER_0_31_165 VGND VGND VPWR VPWR sky130_fd_sc_hd__decap_3
XFILLER_0_54_224 VGND VGND VPWR VPWR sky130_fd_sc_hd__decap_4
XFILLER_0_52_29 VGND VGND VPWR VPWR sky130_fd_sc_hd__decap_8
XFILLER_0_39_221 VGND VGND VPWR VPWR sky130_fd_sc_hd__decap_3
XFILLER_0_22_121 VGND VGND VPWR VPWR sky130_fd_sc_hd__fill_1
X_3121_ VGND VGND VPWR VPWR _1862_ _0054_ _0055_ Nor_gate
X_4170_ VGND VGND VPWR VPWR net20 _1189_ _1137_ Nand_gate
X_3052_ VGND VGND VPWR VPWR _2154_ _1316_ net29 _1667_ Mux
XFILLER_0_26_85 VGND VGND VPWR VPWR sky130_fd_sc_hd__decap_8
XFILLER_0_42_51 VPWR VGND VPWR VGND sky130_ef_sc_hd__decap_12
XFILLER_0_42_40 VGND VGND VPWR VPWR sky130_fd_sc_hd__fill_2
X_2905_ VGND VGND VPWR VPWR _1649_ _2010_ _2009_ Nand_gate
X_2836_ VGND VGND VPWR VPWR _1726_ _1677_ _1942_ Nor_gate
X_3954_ VGND VGND VPWR VPWR _0948_ _0955_ _0956_ Nor_gate
X_3885_ VGND VGND VPWR VPWR _0767_ _0881_ _0825_ Nand_gate
XFILLER_0_53_290 VPWR VGND VPWR VGND sky130_ef_sc_hd__decap_12
X_2767_ VGND VGND VPWR VPWR _1439_ _1873_ _1874_ Nor_gate
X_2698_ VGND VGND VPWR VPWR _1793_ _1806_ _1805_ Nand_gate
XFILLER_0_13_187 VGND VGND VPWR VPWR sky130_fd_sc_hd__decap_6
XTAP_393 VGND VPWR sky130_fd_sc_hd__tapvpwrvgnd_1
XTAP_382 VGND VPWR sky130_fd_sc_hd__tapvpwrvgnd_1
XTAP_371 VGND VPWR sky130_fd_sc_hd__tapvpwrvgnd_1
XTAP_360 VGND VPWR sky130_fd_sc_hd__tapvpwrvgnd_1
X_4299_ VGND VGND VPWR VPWR _1297_ _1329_ _1328_ Nand_gate
X_4368_ VGND VGND VPWR VPWR _0958_ _1403_ _1401_ Nand_gate
X_3319_ VGND VGND VPWR VPWR _1230_ _0270_ _0191_ Nand_gate
XPHY_99 VGND VGND VPWR VPWR sky130_fd_sc_hd__decap_3
XPHY_88 VGND VGND VPWR VPWR sky130_fd_sc_hd__decap_3
XPHY_77 VGND VGND VPWR VPWR sky130_fd_sc_hd__decap_3
XFILLER_0_36_224 VGND VGND VPWR VPWR sky130_fd_sc_hd__decap_6
XPHY_66 VGND VGND VPWR VPWR sky130_fd_sc_hd__decap_3
XPHY_55 VGND VGND VPWR VPWR sky130_fd_sc_hd__decap_3
XPHY_44 VGND VGND VPWR VPWR sky130_fd_sc_hd__decap_3
XPHY_11 VGND VGND VPWR VPWR sky130_fd_sc_hd__decap_3
XPHY_22 VGND VGND VPWR VPWR sky130_fd_sc_hd__decap_3
XPHY_33 VGND VGND VPWR VPWR sky130_fd_sc_hd__decap_3
XFILLER_0_51_238 VPWR VGND VPWR VGND sky130_ef_sc_hd__decap_12
XFILLER_0_8_170 VGND VGND VPWR VPWR sky130_fd_sc_hd__fill_1
X_3670_ VGND VGND VPWR VPWR _0616_ _0650_ _0649_ Nand_gate
X_2621_ VGND VGND VPWR VPWR _1729_ _1727_ _1728_ _1716_ Mux
X_2552_ VGND VGND VPWR VPWR _1661_ _1654_ _1660_ _1633_ Mux
X_2483_ VGND VGND VPWR VPWR _1589_ _1592_ net12 Nand_gate
X_4222_ VGND VGND VPWR VPWR _1245_ _1244_ inverter
XFILLER_0_10_113 VGND VGND VPWR VPWR sky130_fd_sc_hd__decap_6
X_4153_ VGND VGND VPWR VPWR _1166_ _1170_ _1171_ Nor_gate
X_4084_ VGND VGND VPWR VPWR _1094_ _1095_ _1096_ Nor_gate
X_3104_ VGND VGND VPWR VPWR net31 _0036_ _0035_ Nand_gate
X_3035_ VPWR VGND VGND VPWR net30 _2137_ _2136_ Xnor
X_3937_ VGND VGND VPWR VPWR _2159_ _0794_ _0937_ Nor_gate
X_2819_ VGND VGND VPWR VPWR _1925_ _1720_ _1714_ _1716_ Mux
X_3799_ VGND VGND VPWR VPWR _0785_ _0788_ _0789_ Nor_gate
X_3868_ VGND VGND VPWR VPWR _0832_ _0862_ _0864_ Nor_gate
XFILLER_0_41_293 VPWR VGND VPWR VGND sky130_ef_sc_hd__decap_12
XTAP_190 VGND VPWR sky130_fd_sc_hd__tapvpwrvgnd_1
Xinput18 a[25] VGND VGND VPWR VPWR net18 sky130_fd_sc_hd__clkbuf_4
XFILLER_0_24_205 VGND VGND VPWR VPWR sky130_fd_sc_hd__fill_1
Xinput29 a[6] VGND VGND VPWR VPWR net29 sky130_fd_sc_hd__clkbuf_4
XFILLER_0_24_238 VPWR VGND VPWR VGND sky130_ef_sc_hd__decap_12
X_3653_ VGND VGND VPWR VPWR _1862_ _0630_ _0631_ Nor_gate
X_2604_ _1438_ VGND VGND VPWR VPWR _1712_ sky130_fd_sc_hd__clkbuf_4
X_3722_ VGND VGND VPWR VPWR net46 _0706_ _0393_ Nand_gate
XFILLER_0_2_121 VPWR VGND VPWR VGND sky130_ef_sc_hd__decap_12
XFILLER_0_48_83 VGND VGND VPWR VPWR sky130_fd_sc_hd__fill_1
X_4205_ VGND VGND VPWR VPWR _1227_ net57 inverter
X_2535_ VGND VGND VPWR VPWR _1642_ _1644_ _1643_ Nand_gate
X_2466_ VGND VGND VPWR VPWR _1561_ _1574_ _1575_ Nor_gate
X_3584_ VGND VGND VPWR VPWR _0355_ _0555_ _0556_ Nor_gate
X_4136_ VGND VGND VPWR VPWR _1146_ _1152_ _1151_ Nand_gate
X_3018_ VGND VGND VPWR VPWR _2121_ _1800_ _1693_ _1407_ Mux
X_4067_ VGND VGND VPWR VPWR net86 _1077_ inverter
X_2397_ VGND VGND VPWR VPWR _0582_ _0614_ _1506_ Nor_gate
XFILLER_0_58_190 VGND VGND VPWR VPWR sky130_fd_sc_hd__fill_2
XFILLER_0_46_341 VGND VGND VPWR VPWR sky130_fd_sc_hd__fill_2
XFILLER_0_44_19 VGND VGND VPWR VPWR sky130_fd_sc_hd__decap_8
XFILLER_0_52_333 VPWR VGND VPWR VGND sky130_ef_sc_hd__decap_12
XFILLER_0_52_300 VGND VGND VPWR VPWR sky130_fd_sc_hd__decap_8
XFILLER_0_12_219 VGND VGND VPWR VPWR sky130_fd_sc_hd__decap_8
X_2320_ VGND VGND VPWR VPWR _1427_ _1428_ _1429_ Nor_gate
X_2251_ VGND VGND VPWR VPWR net5 net41 _0906_ Nor_gate
X_2182_ VGND VGND VPWR VPWR net22 _0159_ net58 Nand_gate
XFILLER_0_18_97 VGND VGND VPWR VPWR sky130_fd_sc_hd__fill_1
XFILLER_0_18_20 VGND VGND VPWR VPWR sky130_fd_sc_hd__fill_1
XFILLER_0_18_53 VGND VGND VPWR VPWR sky130_fd_sc_hd__fill_1
XFILLER_0_34_85 VGND VGND VPWR VPWR sky130_fd_sc_hd__decap_4
XFILLER_0_34_63 VGND VGND VPWR VPWR sky130_fd_sc_hd__fill_2
XFILLER_0_43_322 VPWR VGND VPWR VGND sky130_ef_sc_hd__decap_12
X_3705_ VGND VGND VPWR VPWR _0687_ _1846_ inverter
X_3636_ VGND VGND VPWR VPWR _0610_ _0612_ _0611_ Nand_gate
X_3567_ VGND VGND VPWR VPWR _0537_ _0481_ inverter
X_2518_ VGND VGND VPWR VPWR _1627_ net2 net3 _1610_ Mux
X_3498_ VGND VGND VPWR VPWR _0464_ _2113_ inverter
X_2449_ VGND VGND VPWR VPWR _0235_ _1558_ _1557_ Nand_gate
XFILLER_0_11_296 VPWR VGND VPWR VGND sky130_ef_sc_hd__decap_12
XFILLER_0_38_127 VGND VGND VPWR VPWR sky130_fd_sc_hd__decap_8
X_4119_ VGND VGND VPWR VPWR net87 _1134_ inverter
XFILLER_0_29_138 VPWR VGND VPWR VGND sky130_ef_sc_hd__decap_12
XFILLER_0_52_141 VGND VGND VPWR VPWR sky130_fd_sc_hd__fill_2
X_3421_ VGND VGND VPWR VPWR _0379_ _0380_ _1770_ Nand_gate
XFILLER_0_20_54 VGND VGND VPWR VPWR sky130_fd_sc_hd__fill_2
X_3283_ VGND VGND VPWR VPWR _0229_ _1930_ _0230_ Nor_gate
XFILLER_0_29_85 VGND VGND VPWR VPWR sky130_fd_sc_hd__fill_2
XFILLER_0_29_52 VGND VGND VPWR VPWR sky130_fd_sc_hd__decap_4
X_2303_ VGND VGND VPWR VPWR _1412_ net64 inverter
X_3352_ VGND VGND VPWR VPWR _0301_ _0304_ _0305_ Nor_gate
X_2234_ VGND VGND VPWR VPWR net9 _0722_ net45 Nand_gate
X_2998_ VGND VGND VPWR VPWR _2101_ _2097_ _2100_ _1419_ Mux
XFILLER_0_35_108 VGND VGND VPWR VPWR sky130_fd_sc_hd__decap_4
X_3619_ VGND VGND VPWR VPWR _1638_ _0595_ _0594_ Nand_gate
X_3970_ VGND VGND VPWR VPWR _0966_ _0973_ _0972_ Nand_gate
XFILLER_0_57_222 VGND VGND VPWR VPWR sky130_fd_sc_hd__fill_2
X_2783_ VGND VGND VPWR VPWR _1585_ _1889_ _1431_ Nand_gate
X_2852_ VGND VGND VPWR VPWR _1816_ _1893_ _1957_ Nor_gate
XFILLER_0_31_86 VGND VGND VPWR VPWR sky130_fd_sc_hd__decap_8
XFILLER_0_31_75 VGND VGND VPWR VPWR sky130_fd_sc_hd__fill_2
X_2921_ VPWR VGND VGND VPWR _1412_ _2025_ _2024_ Xnor
X_3404_ VPWR VGND VGND VPWR _1491_ _0361_ _0360_ Xnor
XFILLER_0_13_314 VGND VGND VPWR VPWR sky130_fd_sc_hd__fill_2
XFILLER_0_13_325 VGND VGND VPWR VPWR sky130_fd_sc_hd__decap_8
XFILLER_0_56_83 VGND VGND VPWR VPWR sky130_fd_sc_hd__fill_1
X_3197_ VGND VGND VPWR VPWR _0137_ _2154_ _0136_ _1938_ Mux
X_3266_ VGND VGND VPWR VPWR _0183_ _0211_ _0212_ Nor_gate
X_3335_ VGND VGND VPWR VPWR _0959_ _0286_ _0285_ Nand_gate
X_2217_ VGND VGND VPWR VPWR _0517_ _0528_ _0538_ Nor_gate
XFILLER_0_48_288 VGND VGND VPWR VPWR sky130_fd_sc_hd__fill_1
XFILLER_0_39_233 VGND VGND VPWR VPWR sky130_fd_sc_hd__fill_2
X_3120_ VGND VGND VPWR VPWR _0052_ _0053_ _0054_ Nor_gate
X_3051_ VGND VGND VPWR VPWR _2000_ _2152_ _2153_ Nor_gate
X_3953_ VGND VGND VPWR VPWR _0950_ _0955_ _0954_ Nand_gate
XFILLER_0_45_269 VGND VGND VPWR VPWR sky130_fd_sc_hd__fill_2
XFILLER_0_45_225 VGND VGND VPWR VPWR sky130_fd_sc_hd__decap_4
X_2904_ VGND VGND VPWR VPWR _2009_ _2005_ _2008_ _1625_ Mux
XFILLER_0_42_85 VGND VGND VPWR VPWR sky130_fd_sc_hd__decap_8
X_2835_ VGND VGND VPWR VPWR _1863_ _1941_ _1940_ Nand_gate
X_2766_ VGND VGND VPWR VPWR _1872_ _1873_ _1789_ Nand_gate
X_3884_ VGND VGND VPWR VPWR _0876_ _0879_ _0880_ Nor_gate
XFILLER_0_13_122 VGND VGND VPWR VPWR sky130_fd_sc_hd__decap_6
XTAP_350 VGND VPWR sky130_fd_sc_hd__tapvpwrvgnd_1
X_2697_ VGND VGND VPWR VPWR _1799_ _1804_ _1805_ Nor_gate
X_4367_ VGND VGND VPWR VPWR net89 _1400_ _1401_ Nor_gate
XFILLER_0_6_41 VPWR VGND VPWR VGND sky130_ef_sc_hd__decap_12
XFILLER_0_6_85 VGND VGND VPWR VPWR sky130_fd_sc_hd__decap_4
X_3318_ _1705_ VGND VGND VPWR VPWR _0269_ sky130_fd_sc_hd__clkbuf_4
XTAP_394 VGND VPWR sky130_fd_sc_hd__tapvpwrvgnd_1
XTAP_383 VGND VPWR sky130_fd_sc_hd__tapvpwrvgnd_1
XTAP_372 VGND VPWR sky130_fd_sc_hd__tapvpwrvgnd_1
XTAP_361 VGND VPWR sky130_fd_sc_hd__tapvpwrvgnd_1
X_4298_ VGND VGND VPWR VPWR _1301_ _1326_ _1328_ Nor_gate
XPHY_12 VGND VGND VPWR VPWR sky130_fd_sc_hd__decap_3
X_3249_ VGND VGND VPWR VPWR _1705_ _0194_ _0193_ Nand_gate
XPHY_89 VGND VGND VPWR VPWR sky130_fd_sc_hd__decap_3
XPHY_78 VGND VGND VPWR VPWR sky130_fd_sc_hd__decap_3
XFILLER_0_36_214 VGND VGND VPWR VPWR sky130_fd_sc_hd__fill_1
XPHY_67 VGND VGND VPWR VPWR sky130_fd_sc_hd__decap_3
XPHY_56 VGND VGND VPWR VPWR sky130_fd_sc_hd__decap_3
XPHY_45 VGND VGND VPWR VPWR sky130_fd_sc_hd__decap_3
XPHY_23 VGND VGND VPWR VPWR sky130_fd_sc_hd__decap_3
XPHY_34 VGND VGND VPWR VPWR sky130_fd_sc_hd__decap_3
XFILLER_0_8_182 VGND VGND VPWR VPWR sky130_fd_sc_hd__fill_1
X_2620_ VGND VGND VPWR VPWR _1728_ net3 _0959_ _1433_ Mux
XFILLER_0_42_239 VGND VGND VPWR VPWR sky130_fd_sc_hd__fill_2
XFILLER_0_27_203 VGND VGND VPWR VPWR sky130_fd_sc_hd__fill_1
XFILLER_0_6_108 VPWR VGND VPWR VGND sky130_ef_sc_hd__decap_12
X_2551_ VGND VGND VPWR VPWR _1660_ _1656_ _1659_ _1589_ Mux
X_2482_ VGND VGND VPWR VPWR _1591_ _1590_ inverter
X_4221_ VGND VGND VPWR VPWR _1565_ _1243_ _1244_ Nor_gate
XFILLER_0_37_96 VGND VGND VPWR VPWR sky130_fd_sc_hd__fill_1
X_4152_ VGND VGND VPWR VPWR _0511_ _1169_ _1170_ Nor_gate
X_4083_ VGND VGND VPWR VPWR _0983_ _1095_ _1034_ Nand_gate
X_3034_ VPWR VGND VGND VPWR net66 _2136_ _2135_ Xnor
X_3103_ VPWR VGND VGND VPWR net67 _0035_ _0034_ Xnor
X_3936_ VGND VGND VPWR VPWR _0932_ _0936_ _0935_ Nand_gate
XFILLER_0_18_269 VGND VGND VPWR VPWR sky130_fd_sc_hd__decap_4
XFILLER_0_41_261 VGND VGND VPWR VPWR sky130_fd_sc_hd__decap_8
X_2749_ VGND VGND VPWR VPWR _1837_ _1855_ _1856_ Nor_gate
X_2818_ _1923_ VGND VGND VPWR VPWR _1924_ sky130_fd_sc_hd__buf_2
XFILLER_0_5_152 VGND VGND VPWR VPWR sky130_fd_sc_hd__fill_2
X_3798_ VGND VGND VPWR VPWR _0676_ _0788_ _0786_ Nand_gate
X_3867_ VGND VGND VPWR VPWR _0862_ _0861_ inverter
XTAP_180 VGND VPWR sky130_fd_sc_hd__tapvpwrvgnd_1
XTAP_191 VGND VPWR sky130_fd_sc_hd__tapvpwrvgnd_1
XFILLER_0_56_309 VPWR VGND VPWR VGND sky130_ef_sc_hd__decap_12
Xinput19 a[26] VGND VGND VPWR VPWR net19 sky130_fd_sc_hd__buf_2
XFILLER_0_58_29 VPWR VGND VPWR VGND sky130_ef_sc_hd__decap_12
X_3652_ VGND VGND VPWR VPWR _0630_ _0629_ inverter
X_2534_ VGND VGND VPWR VPWR net34 net33 _1643_ Nor_gate
XFILLER_0_2_133 VGND VGND VPWR VPWR sky130_fd_sc_hd__decap_6
X_3583_ VGND VGND VPWR VPWR _0282_ _0554_ _0555_ Nor_gate
X_2603_ _1711_ VGND VGND VPWR VPWR net69 sky130_fd_sc_hd__clkbuf_2
XFILLER_0_15_217 VGND VGND VPWR VPWR sky130_fd_sc_hd__fill_2
X_3721_ VGND VGND VPWR VPWR _1511_ _0704_ _0705_ Nor_gate
XFILLER_0_48_95 VPWR VGND VPWR VGND sky130_ef_sc_hd__decap_12
X_4135_ VGND VGND VPWR VPWR _0370_ _1150_ _1151_ Nor_gate
X_4204_ VGND VGND VPWR VPWR net21 net57 _1226_ Nor_gate
X_2465_ VGND VGND VPWR VPWR _1564_ _1573_ _1574_ Nor_gate
X_2396_ VGND VGND VPWR VPWR _0841_ _1505_ _1504_ Nand_gate
XFILLER_0_38_309 VPWR VGND VPWR VGND sky130_ef_sc_hd__decap_12
X_3017_ VGND VGND VPWR VPWR _1650_ _2120_ _2119_ Nand_gate
X_4066_ VGND VGND VPWR VPWR _1040_ _1076_ _1077_ Nor_gate
X_3919_ VGND VGND VPWR VPWR _0888_ _0918_ _0919_ Nor_gate
XFILLER_0_14_250 VGND VGND VPWR VPWR sky130_fd_sc_hd__fill_2
XFILLER_0_56_106 VGND VGND VPWR VPWR sky130_fd_sc_hd__fill_1
XFILLER_0_52_345 VGND VGND VPWR VPWR sky130_fd_sc_hd__fill_2
XFILLER_0_20_297 VGND VGND VPWR VPWR sky130_fd_sc_hd__decap_8
XFILLER_0_20_253 VGND VGND VPWR VPWR sky130_fd_sc_hd__decap_6
X_2250_ VGND VGND VPWR VPWR _0863_ _0884_ _0895_ Nor_gate
X_2181_ VGND VGND VPWR VPWR _0073_ _0149_ _0138_ Nand_gate
XFILLER_0_50_85 VGND VGND VPWR VPWR sky130_fd_sc_hd__decap_4
XFILLER_0_50_41 VPWR VGND VPWR VGND sky130_ef_sc_hd__decap_12
XFILLER_0_43_334 VGND VGND VPWR VPWR sky130_fd_sc_hd__fill_2
X_3704_ _0108_ VGND VGND VPWR VPWR _0686_ sky130_fd_sc_hd__clkbuf_4
X_2517_ VGND VGND VPWR VPWR _1626_ net31 _1475_ _1610_ Mux
XFILLER_0_43_345 VGND VGND VPWR VPWR sky130_fd_sc_hd__fill_2
X_3497_ VGND VGND VPWR VPWR _0455_ _0461_ _0462_ Nor_gate
X_3566_ VGND VGND VPWR VPWR _0536_ _0429_ inverter
X_3635_ VGND VGND VPWR VPWR _0558_ _0611_ _0563_ Nand_gate
XFILLER_0_52_3 VPWR VGND VPWR VGND sky130_ef_sc_hd__decap_12
X_2448_ VGND VGND VPWR VPWR _1545_ _1557_ _1556_ Nand_gate
X_4118_ VGND VGND VPWR VPWR _1102_ _1132_ _1134_ Nor_gate
X_2379_ VGND VGND VPWR VPWR _1014_ _1487_ _1488_ Nor_gate
X_4049_ VGND VGND VPWR VPWR _1051_ _1059_ _1058_ Nand_gate
XFILLER_0_19_320 VGND VGND VPWR VPWR sky130_fd_sc_hd__decap_8
XFILLER_0_44_109 VGND VGND VPWR VPWR sky130_fd_sc_hd__fill_1
XFILLER_0_37_194 VGND VGND VPWR VPWR sky130_fd_sc_hd__decap_8
XFILLER_0_37_172 VGND VGND VPWR VPWR sky130_fd_sc_hd__fill_2
X_3420_ _1606_ VGND VGND VPWR VPWR _0379_ sky130_fd_sc_hd__clkbuf_4
X_3351_ VGND VGND VPWR VPWR _0220_ _0303_ _0304_ Nor_gate
X_3282_ _1625_ VGND VGND VPWR VPWR _0229_ sky130_fd_sc_hd__buf_2
X_2302_ VGND VGND VPWR VPWR _1411_ _1410_ inverter
X_2233_ VGND VGND VPWR VPWR _0636_ _0712_ _0701_ Nand_gate
XFILLER_0_45_74 VGND VGND VPWR VPWR sky130_fd_sc_hd__fill_1
XFILLER_0_0_21 VGND VGND VPWR VPWR sky130_fd_sc_hd__decap_6
XFILLER_0_0_43 VGND VGND VPWR VPWR sky130_fd_sc_hd__fill_2
X_2997_ VGND VGND VPWR VPWR _2100_ _1829_ _2099_ _1712_ Mux
XFILLER_0_31_304 VGND VGND VPWR VPWR sky130_fd_sc_hd__fill_1
XFILLER_0_28_161 VPWR VGND VPWR VGND sky130_ef_sc_hd__decap_12
XFILLER_0_9_74 VGND VGND VPWR VPWR sky130_fd_sc_hd__decap_8
XFILLER_0_9_96 VGND VGND VPWR VPWR sky130_fd_sc_hd__fill_1
XFILLER_0_31_337 VGND VGND VPWR VPWR sky130_fd_sc_hd__decap_8
X_3618_ _1702_ VGND VGND VPWR VPWR _0594_ sky130_fd_sc_hd__clkbuf_4
X_3549_ VGND VGND VPWR VPWR _1700_ _0040_ _0519_ Nor_gate
XFILLER_0_34_197 VGND VGND VPWR VPWR sky130_fd_sc_hd__decap_6
X_2920_ VGND VGND VPWR VPWR _1813_ _2023_ _2024_ Nor_gate
XFILLER_0_15_55 VGND VGND VPWR VPWR sky130_fd_sc_hd__fill_1
XFILLER_0_15_99 VGND VGND VPWR VPWR sky130_fd_sc_hd__decap_4
X_2851_ VGND VGND VPWR VPWR _1956_ _1812_ inverter
XFILLER_0_25_142 VPWR VGND VPWR VGND sky130_ef_sc_hd__decap_12
X_2782_ VGND VGND VPWR VPWR net91 _1888_ inverter
XFILLER_0_0_253 VGND VGND VPWR VPWR sky130_fd_sc_hd__fill_2
XFILLER_0_0_231 VGND VGND VPWR VPWR sky130_fd_sc_hd__decap_8
X_3334_ VGND VGND VPWR VPWR _0285_ _0284_ inverter
X_3403_ VPWR VGND VGND VPWR _1492_ _0360_ _0359_ Xnor
XFILLER_0_13_337 VGND VGND VPWR VPWR sky130_fd_sc_hd__decap_8
X_3196_ VGND VGND VPWR VPWR _0136_ _1475_ net31 _1667_ Mux
X_3265_ VGND VGND VPWR VPWR _0190_ _0211_ _0210_ Nand_gate
XFILLER_0_15_3 VPWR VGND VPWR VGND sky130_ef_sc_hd__decap_12
X_2216_ VGND VGND VPWR VPWR net16 net52 _0528_ Nor_gate
XFILLER_0_48_223 VGND VGND VPWR VPWR sky130_fd_sc_hd__decap_8
XFILLER_0_31_145 VPWR VGND VPWR VGND sky130_ef_sc_hd__decap_12
XFILLER_0_31_101 VGND VGND VPWR VPWR sky130_fd_sc_hd__fill_1
XFILLER_0_16_120 VGND VGND VPWR VPWR sky130_fd_sc_hd__decap_8
XFILLER_0_16_164 VGND VGND VPWR VPWR sky130_fd_sc_hd__decap_4
XFILLER_0_16_175 VGND VGND VPWR VPWR sky130_fd_sc_hd__decap_3
XFILLER_0_54_237 VPWR VGND VPWR VGND sky130_ef_sc_hd__decap_12
X_3050_ VGND VGND VPWR VPWR _1924_ _2151_ _2152_ Nor_gate
XFILLER_0_26_65 VGND VGND VPWR VPWR sky130_fd_sc_hd__fill_1
XFILLER_0_26_43 VGND VGND VPWR VPWR sky130_fd_sc_hd__fill_2
X_2903_ VGND VGND VPWR VPWR _2008_ _2007_ _1632_ _1605_ Mux
XFILLER_0_45_204 VGND VGND VPWR VPWR sky130_fd_sc_hd__decap_4
XFILLER_0_26_98 VGND VGND VPWR VPWR sky130_fd_sc_hd__decap_3
X_3952_ VGND VGND VPWR VPWR _0954_ _0953_ inverter
X_3883_ VGND VGND VPWR VPWR _0671_ _0878_ _0879_ Nor_gate
X_2834_ VGND VGND VPWR VPWR _1637_ _1939_ _1940_ Nor_gate
X_2696_ VGND VGND VPWR VPWR _1804_ _1803_ inverter
X_2765_ VGND VGND VPWR VPWR _1645_ net36 _1872_ Nor_gate
XFILLER_0_5_345 VGND VGND VPWR VPWR sky130_fd_sc_hd__fill_2
XTAP_384 VGND VPWR sky130_fd_sc_hd__tapvpwrvgnd_1
XTAP_373 VGND VPWR sky130_fd_sc_hd__tapvpwrvgnd_1
XTAP_362 VGND VPWR sky130_fd_sc_hd__tapvpwrvgnd_1
XTAP_351 VGND VPWR sky130_fd_sc_hd__tapvpwrvgnd_1
XTAP_340 VGND VPWR sky130_fd_sc_hd__tapvpwrvgnd_1
X_4297_ VGND VGND VPWR VPWR _1310_ _1326_ _1325_ Nand_gate
X_4366_ VGND VGND VPWR VPWR _1077_ _1400_ _1134_ Nand_gate
XFILLER_0_6_53 VPWR VGND VPWR VGND sky130_ef_sc_hd__decap_12
X_3317_ VGND VGND VPWR VPWR _1230_ _0191_ _0267_ Nor_gate
XTAP_395 VGND VPWR sky130_fd_sc_hd__tapvpwrvgnd_1
X_3179_ VGND VGND VPWR VPWR _0107_ _0118_ _0117_ Nand_gate
XPHY_46 VGND VGND VPWR VPWR sky130_fd_sc_hd__decap_3
XPHY_13 VGND VGND VPWR VPWR sky130_fd_sc_hd__decap_3
XPHY_24 VGND VGND VPWR VPWR sky130_fd_sc_hd__decap_3
X_3248_ VGND VGND VPWR VPWR _0150_ _0193_ _0122_ Nand_gate
XPHY_35 VGND VGND VPWR VPWR sky130_fd_sc_hd__decap_3
XFILLER_0_51_218 VGND VGND VPWR VPWR sky130_fd_sc_hd__fill_1
XPHY_79 VGND VGND VPWR VPWR sky130_fd_sc_hd__decap_3
XFILLER_0_36_204 VGND VGND VPWR VPWR sky130_fd_sc_hd__fill_1
XPHY_68 VGND VGND VPWR VPWR sky130_fd_sc_hd__decap_3
XPHY_57 VGND VGND VPWR VPWR sky130_fd_sc_hd__decap_3
XFILLER_0_8_161 VGND VGND VPWR VPWR sky130_fd_sc_hd__decap_3
XFILLER_0_8_194 VGND VGND VPWR VPWR sky130_fd_sc_hd__fill_2
XFILLER_0_42_218 VPWR VGND VPWR VGND sky130_ef_sc_hd__decap_12
X_2550_ VGND VGND VPWR VPWR _1659_ _1657_ _1658_ net37 Mux
XFILLER_0_2_304 VGND VGND VPWR VPWR sky130_fd_sc_hd__decap_4
XFILLER_0_49_9 VPWR VGND VPWR VGND sky130_ef_sc_hd__decap_12
X_2481_ VGND VGND VPWR VPWR _1589_ net12 _1590_ Nor_gate
XFILLER_0_37_20 VGND VGND VPWR VPWR sky130_fd_sc_hd__fill_1
X_4151_ VGND VGND VPWR VPWR _1169_ _0513_ _0512_ _1168_ Mux
X_4220_ VPWR VGND VGND VPWR net58 _1243_ _1242_ Xnor
X_3033_ VGND VGND VPWR VPWR _2072_ _2134_ _2135_ Nor_gate
X_4082_ VGND VGND VPWR VPWR _1090_ _1093_ _1094_ Nor_gate
X_3102_ VGND VGND VPWR VPWR _1813_ _0033_ _0034_ Nor_gate
X_3935_ VGND VGND VPWR VPWR _0370_ _0934_ _0935_ Nor_gate
X_3866_ VGND VGND VPWR VPWR _0839_ _0860_ _0861_ Nor_gate
X_2748_ VGND VGND VPWR VPWR _1424_ _1854_ _1855_ Nor_gate
X_2817_ VGND VGND VPWR VPWR _1765_ _1922_ _1923_ Nor_gate
X_2679_ VGND VGND VPWR VPWR _1787_ _1786_ inverter
X_3797_ VGND VGND VPWR VPWR _0767_ _0786_ _0784_ Nand_gate
X_4349_ VGND VGND VPWR VPWR _2022_ _1382_ _1381_ Nand_gate
XTAP_170 VGND VPWR sky130_fd_sc_hd__tapvpwrvgnd_1
XTAP_181 VGND VPWR sky130_fd_sc_hd__tapvpwrvgnd_1
XTAP_192 VGND VPWR sky130_fd_sc_hd__tapvpwrvgnd_1
XFILLER_0_32_251 VGND VGND VPWR VPWR sky130_fd_sc_hd__fill_1
XFILLER_0_24_218 VGND VGND VPWR VPWR sky130_fd_sc_hd__fill_1
XFILLER_0_17_281 VGND VGND VPWR VPWR sky130_fd_sc_hd__decap_6
XFILLER_0_32_295 VPWR VGND VPWR VGND sky130_ef_sc_hd__decap_12
XFILLER_0_23_22 VGND VGND VPWR VPWR sky130_fd_sc_hd__fill_2
X_3720_ VGND VGND VPWR VPWR _1682_ _0703_ _0704_ Nor_gate
X_3651_ VGND VGND VPWR VPWR _0629_ _0139_ _0628_ _1614_ Mux
XFILLER_0_23_251 VGND VGND VPWR VPWR sky130_fd_sc_hd__fill_2
X_2533_ VGND VGND VPWR VPWR net35 _1599_ _1642_ Nor_gate
X_2602_ VGND VGND VPWR VPWR _1604_ _1711_ _1710_ Nand_gate
X_3582_ VGND VGND VPWR VPWR _0415_ _0554_ _0553_ Nand_gate
XFILLER_0_48_85 VGND VGND VPWR VPWR sky130_fd_sc_hd__fill_1
XFILLER_0_48_41 VGND VGND VPWR VPWR sky130_fd_sc_hd__decap_6
X_4134_ VGND VGND VPWR VPWR _1148_ _1149_ _1150_ Nor_gate
X_4203_ VGND VGND VPWR VPWR _0313_ _1225_ _0741_ Nand_gate
X_2464_ VGND VGND VPWR VPWR _1566_ _1572_ _1573_ Nor_gate
X_2395_ VGND VGND VPWR VPWR _1470_ _1504_ _1503_ Nand_gate
X_3016_ VGND VGND VPWR VPWR _2111_ _2119_ _2118_ Nand_gate
X_4065_ VGND VGND VPWR VPWR _1076_ _1075_ inverter
XFILLER_0_46_321 VPWR VGND VPWR VGND sky130_ef_sc_hd__decap_12
X_3849_ VGND VGND VPWR VPWR _2049_ _0843_ _0842_ Nand_gate
X_3918_ VGND VGND VPWR VPWR _0896_ _0918_ _0916_ Nand_gate
XFILLER_0_49_181 VGND VGND VPWR VPWR sky130_fd_sc_hd__decap_4
X_2180_ VGND VGND VPWR VPWR _0116_ _0138_ _0127_ Nand_gate
XFILLER_0_34_32 VGND VGND VPWR VPWR sky130_fd_sc_hd__fill_1
XFILLER_0_50_53 VPWR VGND VPWR VGND sky130_ef_sc_hd__decap_12
X_3634_ VGND VGND VPWR VPWR _0608_ _0609_ _0610_ Nor_gate
X_3703_ VGND VGND VPWR VPWR _0682_ _0685_ _0684_ Nand_gate
X_2447_ VGND VGND VPWR VPWR _0289_ _1556_ _1555_ Nand_gate
X_3496_ VGND VGND VPWR VPWR _1924_ _0460_ _0461_ Nor_gate
X_2516_ _1624_ VGND VGND VPWR VPWR _1625_ sky130_fd_sc_hd__buf_2
X_3565_ VGND VGND VPWR VPWR _0531_ _0535_ _0534_ Nand_gate
X_4048_ VGND VGND VPWR VPWR _0228_ _1056_ _1058_ Nor_gate
XFILLER_0_45_3 VPWR VGND VPWR VGND sky130_ef_sc_hd__decap_12
X_4117_ VGND VGND VPWR VPWR _1106_ _1132_ _1131_ Nand_gate
X_2378_ VGND VGND VPWR VPWR _1487_ net43 inverter
XFILLER_0_46_173 VGND VGND VPWR VPWR sky130_fd_sc_hd__decap_8
XFILLER_0_46_162 VGND VGND VPWR VPWR sky130_fd_sc_hd__decap_4
XFILLER_0_34_346 VGND VGND VPWR VPWR sky130_fd_sc_hd__fill_1
XFILLER_0_34_313 VGND VGND VPWR VPWR sky130_fd_sc_hd__decap_4
XFILLER_0_37_184 VGND VGND VPWR VPWR sky130_fd_sc_hd__fill_1
XFILLER_0_25_346 VGND VGND VPWR VPWR sky130_fd_sc_hd__fill_1
XFILLER_0_25_324 VGND VGND VPWR VPWR sky130_fd_sc_hd__decap_8
XFILLER_0_20_12 VGND VGND VPWR VPWR sky130_fd_sc_hd__fill_1
X_2301_ net28 VGND VGND VPWR VPWR _1410_ sky130_fd_sc_hd__buf_2
XFILLER_0_20_45 VGND VGND VPWR VPWR sky130_fd_sc_hd__decap_3
X_3350_ VGND VGND VPWR VPWR _0303_ _0302_ inverter
X_3281_ _1982_ VGND VGND VPWR VPWR _0228_ sky130_fd_sc_hd__clkbuf_4
X_2232_ VGND VGND VPWR VPWR _0668_ _0701_ _0690_ Nand_gate
XFILLER_0_0_55 VGND VGND VPWR VPWR sky130_fd_sc_hd__fill_1
XFILLER_0_0_77 VGND VGND VPWR VPWR sky130_fd_sc_hd__decap_6
X_2996_ VGND VGND VPWR VPWR _2099_ _2006_ _2098_ _1628_ Mux
XFILLER_0_43_132 VGND VGND VPWR VPWR sky130_fd_sc_hd__decap_8
XFILLER_0_43_121 VGND VGND VPWR VPWR sky130_fd_sc_hd__fill_2
X_3617_ VGND VGND VPWR VPWR _2147_ _0592_ _1765_ Nand_gate
XFILLER_0_28_195 VGND VGND VPWR VPWR sky130_fd_sc_hd__fill_1
XFILLER_0_28_173 VGND VGND VPWR VPWR sky130_fd_sc_hd__fill_2
XFILLER_0_3_240 VPWR VGND VPWR VGND sky130_ef_sc_hd__decap_12
XFILLER_0_16_313 VGND VGND VPWR VPWR sky130_fd_sc_hd__decap_6
X_3548_ VGND VGND VPWR VPWR net43 _0518_ _0393_ Nand_gate
XFILLER_0_3_284 VGND VGND VPWR VPWR sky130_fd_sc_hd__fill_1
X_3479_ VGND VGND VPWR VPWR _1489_ _0001_ _0443_ Nor_gate
XFILLER_0_34_121 VGND VGND VPWR VPWR sky130_fd_sc_hd__fill_2
XFILLER_0_34_176 VGND VGND VPWR VPWR sky130_fd_sc_hd__fill_1
XFILLER_0_57_279 VGND VGND VPWR VPWR sky130_fd_sc_hd__fill_1
X_2850_ _1955_ VGND VGND VPWR VPWR net94 sky130_fd_sc_hd__buf_1
XFILLER_0_15_23 VGND VGND VPWR VPWR sky130_fd_sc_hd__fill_1
XFILLER_0_40_113 VGND VGND VPWR VPWR sky130_fd_sc_hd__decap_4
X_2781_ VGND VGND VPWR VPWR _1820_ _1887_ _1888_ Nor_gate
XFILLER_0_31_11 VGND VGND VPWR VPWR sky130_fd_sc_hd__fill_1
XFILLER_0_25_187 VGND VGND VPWR VPWR sky130_fd_sc_hd__decap_3
XFILLER_0_25_154 VGND VGND VPWR VPWR sky130_fd_sc_hd__decap_4
XFILLER_0_25_121 VGND VGND VPWR VPWR sky130_fd_sc_hd__fill_1
XFILLER_0_56_41 VPWR VGND VPWR VGND sky130_ef_sc_hd__decap_12
X_3264_ VGND VGND VPWR VPWR _0195_ _0209_ _0210_ Nor_gate
X_3402_ VGND VGND VPWR VPWR _0355_ _0358_ _0359_ Nor_gate
X_3333_ VPWR VGND VGND VPWR net40 _0284_ _0283_ Xnor
XFILLER_0_56_85 VGND VGND VPWR VPWR sky130_fd_sc_hd__decap_8
X_3195_ _1614_ VGND VGND VPWR VPWR _0135_ sky130_fd_sc_hd__clkbuf_4
X_2215_ VGND VGND VPWR VPWR _0517_ _0506_ inverter
XFILLER_0_48_235 VGND VGND VPWR VPWR sky130_fd_sc_hd__decap_8
XFILLER_0_48_213 VGND VGND VPWR VPWR sky130_fd_sc_hd__fill_1
X_2979_ VGND VGND VPWR VPWR _2080_ _2082_ _2081_ Nand_gate
XFILLER_0_8_321 VPWR VGND VPWR VGND sky130_ef_sc_hd__decap_12
XFILLER_0_31_157 VGND VGND VPWR VPWR sky130_fd_sc_hd__decap_8
XFILLER_0_31_113 VGND VGND VPWR VPWR sky130_fd_sc_hd__decap_8
XFILLER_0_6_7 VPWR VGND VPWR VGND sky130_ef_sc_hd__decap_12
XFILLER_0_54_249 VGND VGND VPWR VPWR sky130_fd_sc_hd__decap_3
XFILLER_0_47_290 VGND VGND VPWR VPWR sky130_fd_sc_hd__decap_4
XFILLER_0_22_146 VGND VGND VPWR VPWR sky130_fd_sc_hd__fill_1
XFILLER_0_26_55 VGND VGND VPWR VPWR sky130_fd_sc_hd__decap_6
X_2833_ VGND VGND VPWR VPWR _1939_ _1796_ _1937_ _1938_ Mux
X_2902_ VGND VGND VPWR VPWR _2007_ _1651_ _2006_ _1628_ Mux
XFILLER_0_45_238 VPWR VGND VPWR VGND sky130_ef_sc_hd__decap_12
X_3882_ VGND VGND VPWR VPWR _0877_ _0878_ _0772_ Nand_gate
X_3951_ VGND VGND VPWR VPWR _0528_ _0952_ _0953_ Nor_gate
X_2764_ VGND VGND VPWR VPWR _1870_ _1677_ _1871_ Nor_gate
X_2695_ VGND VGND VPWR VPWR _1589_ _1803_ _1802_ Nand_gate
XTAP_396 VGND VPWR sky130_fd_sc_hd__tapvpwrvgnd_1
XTAP_385 VGND VPWR sky130_fd_sc_hd__tapvpwrvgnd_1
XTAP_374 VGND VPWR sky130_fd_sc_hd__tapvpwrvgnd_1
XTAP_363 VGND VPWR sky130_fd_sc_hd__tapvpwrvgnd_1
XTAP_352 VGND VPWR sky130_fd_sc_hd__tapvpwrvgnd_1
XTAP_341 VGND VPWR sky130_fd_sc_hd__tapvpwrvgnd_1
XTAP_330 VGND VPWR sky130_fd_sc_hd__tapvpwrvgnd_1
X_4296_ VGND VGND VPWR VPWR _1313_ _1324_ _1325_ Nor_gate
X_4365_ VGND VGND VPWR VPWR _1393_ _1399_ _1398_ Nand_gate
XFILLER_0_6_65 VGND VGND VPWR VPWR sky130_fd_sc_hd__decap_3
X_3247_ VGND VGND VPWR VPWR _0150_ _0122_ _0191_ Nor_gate
X_3316_ VGND VGND VPWR VPWR _0260_ _0266_ _0265_ Nand_gate
XPHY_69 VGND VGND VPWR VPWR sky130_fd_sc_hd__decap_3
X_3178_ VGND VGND VPWR VPWR _1982_ _0117_ _0115_ Nand_gate
XPHY_58 VGND VGND VPWR VPWR sky130_fd_sc_hd__decap_3
XPHY_47 VGND VGND VPWR VPWR sky130_fd_sc_hd__decap_3
XPHY_14 VGND VGND VPWR VPWR sky130_fd_sc_hd__decap_3
XPHY_25 VGND VGND VPWR VPWR sky130_fd_sc_hd__decap_3
XPHY_36 VGND VGND VPWR VPWR sky130_fd_sc_hd__decap_3
XFILLER_0_29_290 VGND VGND VPWR VPWR sky130_fd_sc_hd__decap_6
XFILLER_0_12_190 VGND VGND VPWR VPWR sky130_fd_sc_hd__fill_1
X_2480_ _1588_ VGND VGND VPWR VPWR _1589_ sky130_fd_sc_hd__buf_4
X_4150_ VGND VGND VPWR VPWR _1544_ _1167_ _1168_ Nor_gate
X_3101_ VGND VGND VPWR VPWR _1699_ _0032_ _0033_ Nor_gate
X_4081_ VGND VGND VPWR VPWR _1091_ _1093_ _1092_ Nand_gate
Xoutput90 net90 VGND VGND VPWR VPWR result[29] sky130_fd_sc_hd__clkbuf_4
XFILLER_0_10_138 VGND VGND VPWR VPWR sky130_fd_sc_hd__fill_2
X_3032_ VGND VGND VPWR VPWR _1391_ _1813_ _2134_ Nor_gate
XFILLER_0_26_271 VGND VGND VPWR VPWR sky130_fd_sc_hd__fill_1
X_2816_ _1921_ VGND VGND VPWR VPWR _1922_ sky130_fd_sc_hd__buf_2
X_3934_ VGND VGND VPWR VPWR _0837_ _0933_ _0934_ Nor_gate
XFILLER_0_5_110 VGND VGND VPWR VPWR sky130_fd_sc_hd__fill_2
XFILLER_0_5_132 VPWR VGND VPWR VGND sky130_ef_sc_hd__decap_12
X_3796_ VGND VGND VPWR VPWR _0767_ _0784_ _0785_ Nor_gate
X_3865_ VGND VGND VPWR VPWR _0854_ _0860_ _0859_ Nand_gate
X_2747_ VGND VGND VPWR VPWR _1854_ _1853_ _1843_ _1712_ Mux
X_2678_ VGND VGND VPWR VPWR _1590_ _1694_ _1786_ Nor_gate
XFILLER_0_5_198 VGND VGND VPWR VPWR sky130_fd_sc_hd__decap_4
X_4279_ VGND VGND VPWR VPWR _1307_ _0900_ _1306_ _0135_ Mux
X_4348_ VGND VGND VPWR VPWR net94 _1379_ _1381_ Nor_gate
XTAP_160 VGND VPWR sky130_fd_sc_hd__tapvpwrvgnd_1
XTAP_171 VGND VPWR sky130_fd_sc_hd__tapvpwrvgnd_1
XTAP_182 VGND VPWR sky130_fd_sc_hd__tapvpwrvgnd_1
XTAP_193 VGND VPWR sky130_fd_sc_hd__tapvpwrvgnd_1
XFILLER_0_17_293 VGND VGND VPWR VPWR sky130_fd_sc_hd__decap_3
X_3650_ VGND VGND VPWR VPWR _0628_ _0404_ _0627_ _1606_ Mux
XFILLER_0_55_333 VGND VGND VPWR VPWR sky130_fd_sc_hd__decap_3
XFILLER_0_23_89 VGND VGND VPWR VPWR sky130_fd_sc_hd__fill_1
XFILLER_0_23_78 VGND VGND VPWR VPWR sky130_fd_sc_hd__decap_4
X_2532_ VGND VGND VPWR VPWR _1623_ _1640_ _1641_ Nor_gate
X_2601_ VGND VGND VPWR VPWR _1675_ _1709_ _1710_ Nor_gate
X_4202_ VGND VGND VPWR VPWR _0113_ _1223_ _1224_ Nor_gate
XFILLER_0_23_274 VGND VGND VPWR VPWR sky130_fd_sc_hd__fill_1
X_2463_ VGND VGND VPWR VPWR _1569_ _1571_ _1572_ Nor_gate
XFILLER_0_2_146 VPWR VGND VPWR VGND sky130_ef_sc_hd__decap_12
X_3581_ VGND VGND VPWR VPWR net43 net42 _0553_ Nor_gate
X_4133_ VGND VGND VPWR VPWR net19 _1149_ net20 Nand_gate
X_3015_ VGND VGND VPWR VPWR _2118_ _2117_ inverter
X_4064_ VGND VGND VPWR VPWR _1047_ _1074_ _1075_ Nor_gate
XFILLER_0_3_55 VGND VGND VPWR VPWR sky130_fd_sc_hd__fill_1
X_2394_ VGND VGND VPWR VPWR _1486_ _1502_ _1503_ Nor_gate
XFILLER_0_58_182 VGND VGND VPWR VPWR sky130_fd_sc_hd__decap_8
XFILLER_0_46_333 VGND VGND VPWR VPWR sky130_fd_sc_hd__decap_8
X_3848_ VGND VGND VPWR VPWR _0738_ _0840_ _0842_ Nor_gate
X_3917_ VGND VGND VPWR VPWR _0909_ _0915_ _0916_ Nor_gate
X_3779_ VGND VGND VPWR VPWR _0763_ _0766_ _0767_ Nor_gate
XFILLER_0_14_285 VGND VGND VPWR VPWR sky130_fd_sc_hd__fill_2
XFILLER_0_20_244 VGND VGND VPWR VPWR sky130_fd_sc_hd__fill_2
XFILLER_0_47_119 VGND VGND VPWR VPWR sky130_fd_sc_hd__fill_2
XFILLER_0_34_99 VGND VGND VPWR VPWR sky130_fd_sc_hd__decap_6
XFILLER_0_34_77 VGND VGND VPWR VPWR sky130_fd_sc_hd__fill_1
XFILLER_0_55_196 VGND VGND VPWR VPWR sky130_fd_sc_hd__fill_1
XFILLER_0_55_163 VGND VGND VPWR VPWR sky130_fd_sc_hd__decap_4
XFILLER_0_50_65 VGND VGND VPWR VPWR sky130_fd_sc_hd__decap_8
X_3633_ VGND VGND VPWR VPWR _0733_ _0606_ _0609_ Nor_gate
X_3702_ VGND VGND VPWR VPWR _0370_ _0683_ _0684_ Nor_gate
X_2446_ VGND VGND VPWR VPWR _1547_ _1555_ _1554_ Nand_gate
X_3495_ VGND VGND VPWR VPWR _1982_ _0459_ _0460_ Nor_gate
X_2515_ net62 VGND VGND VPWR VPWR _1624_ sky130_fd_sc_hd__clkbuf_4
X_3564_ VGND VGND VPWR VPWR _0429_ _0533_ _0534_ Nor_gate
XFILLER_0_11_222 VGND VGND VPWR VPWR sky130_fd_sc_hd__fill_2
X_4047_ VGND VGND VPWR VPWR _0229_ _1055_ _1056_ Nor_gate
XFILLER_0_38_3 VGND VGND VPWR VPWR sky130_fd_sc_hd__decap_4
X_4116_ VGND VGND VPWR VPWR _1114_ _1130_ _1131_ Nor_gate
X_2377_ VGND VGND VPWR VPWR _1078_ _1485_ _1486_ Nor_gate
XFILLER_0_34_303 VGND VGND VPWR VPWR sky130_fd_sc_hd__decap_4
XFILLER_0_29_119 VGND VGND VPWR VPWR sky130_fd_sc_hd__fill_1
XFILLER_0_29_108 VGND VGND VPWR VPWR sky130_fd_sc_hd__fill_1
XFILLER_0_52_177 VGND VGND VPWR VPWR sky130_fd_sc_hd__decap_4
X_3280_ VGND VGND VPWR VPWR _0102_ _0227_ _1908_ Nand_gate
X_2300_ VGND VGND VPWR VPWR _1370_ _1409_ _1408_ Nand_gate
XFILLER_0_20_79 VGND VGND VPWR VPWR sky130_fd_sc_hd__fill_2
X_2231_ VGND VGND VPWR VPWR _0679_ _0690_ net46 Nand_gate
XFILLER_0_45_87 VGND VGND VPWR VPWR sky130_fd_sc_hd__decap_8
XFILLER_0_24_9 VGND VGND VPWR VPWR sky130_fd_sc_hd__fill_1
X_2995_ VGND VGND VPWR VPWR _2098_ _0452_ _0387_ _1615_ Mux
XFILLER_0_43_199 VGND VGND VPWR VPWR sky130_fd_sc_hd__decap_8
X_3616_ VGND VGND VPWR VPWR net44 _0591_ _2002_ Nand_gate
XFILLER_0_3_252 VGND VGND VPWR VPWR sky130_fd_sc_hd__fill_2
XFILLER_0_9_21 VPWR VGND VPWR VGND sky130_ef_sc_hd__decap_12
X_3547_ VGND VGND VPWR VPWR _1046_ _0515_ _0516_ Nor_gate
X_3478_ VGND VGND VPWR VPWR _0438_ _0440_ _0442_ Nor_gate
X_2429_ VGND VGND VPWR VPWR _1530_ _1537_ _1538_ Nor_gate
XFILLER_0_34_133 VGND VGND VPWR VPWR sky130_fd_sc_hd__decap_6
XFILLER_0_57_214 VGND VGND VPWR VPWR sky130_fd_sc_hd__decap_8
XFILLER_0_57_203 VGND VGND VPWR VPWR sky130_fd_sc_hd__fill_2
XFILLER_0_15_57 VGND VGND VPWR VPWR sky130_fd_sc_hd__decap_8
X_2780_ VGND VGND VPWR VPWR _1850_ _1887_ _1886_ Nand_gate
XFILLER_0_25_199 VGND VGND VPWR VPWR sky130_fd_sc_hd__fill_1
X_3401_ VGND VGND VPWR VPWR net40 _0357_ _0358_ Nor_gate
XFILLER_0_56_53 VPWR VGND VPWR VGND sky130_ef_sc_hd__decap_12
X_3263_ VGND VGND VPWR VPWR _0202_ _0209_ _0208_ Nand_gate
X_3194_ VGND VGND VPWR VPWR _0124_ _0133_ _0134_ Nor_gate
X_3332_ VGND VGND VPWR VPWR _0215_ _0283_ _0282_ Nand_gate
X_2214_ VGND VGND VPWR VPWR net16 _0506_ net52 Nand_gate
X_2978_ VGND VGND VPWR VPWR _1961_ _1959_ _2081_ Nor_gate
XFILLER_0_8_333 VPWR VGND VPWR VGND sky130_ef_sc_hd__decap_12
XFILLER_0_16_111 VGND VGND VPWR VPWR sky130_fd_sc_hd__fill_2
XFILLER_0_16_144 VGND VGND VPWR VPWR sky130_fd_sc_hd__decap_3
XFILLER_0_31_169 VGND VGND VPWR VPWR sky130_fd_sc_hd__decap_4
XFILLER_0_54_206 VPWR VGND VPWR VGND sky130_ef_sc_hd__decap_12
XFILLER_0_39_225 VGND VGND VPWR VPWR sky130_fd_sc_hd__decap_8
XFILLER_0_10_309 VGND VGND VPWR VPWR sky130_fd_sc_hd__decap_3
XFILLER_0_26_78 VGND VGND VPWR VPWR sky130_fd_sc_hd__decap_6
X_3950_ VGND VGND VPWR VPWR _0511_ _0951_ _0952_ Nor_gate
X_2763_ _1606_ VGND VGND VPWR VPWR _1870_ sky130_fd_sc_hd__clkbuf_4
X_2832_ _1432_ VGND VGND VPWR VPWR _1938_ sky130_fd_sc_hd__clkbuf_4
X_2901_ VGND VGND VPWR VPWR _2006_ _0679_ _0582_ _1615_ Mux
XFILLER_0_42_66 VPWR VGND VPWR VGND sky130_ef_sc_hd__decap_12
XFILLER_0_38_280 VPWR VGND VPWR VGND sky130_ef_sc_hd__decap_12
X_3881_ VGND VGND VPWR VPWR _0877_ _0672_ inverter
X_2694_ VGND VGND VPWR VPWR _1677_ _1802_ _1801_ Nand_gate
X_4364_ VGND VGND VPWR VPWR _1394_ _1397_ _1398_ Nor_gate
XTAP_397 VGND VPWR sky130_fd_sc_hd__tapvpwrvgnd_1
XTAP_386 VGND VPWR sky130_fd_sc_hd__tapvpwrvgnd_1
XTAP_375 VGND VPWR sky130_fd_sc_hd__tapvpwrvgnd_1
XTAP_364 VGND VPWR sky130_fd_sc_hd__tapvpwrvgnd_1
XTAP_353 VGND VPWR sky130_fd_sc_hd__tapvpwrvgnd_1
XTAP_342 VGND VPWR sky130_fd_sc_hd__tapvpwrvgnd_1
XTAP_331 VGND VPWR sky130_fd_sc_hd__tapvpwrvgnd_1
XTAP_320 VGND VPWR sky130_fd_sc_hd__tapvpwrvgnd_1
X_3246_ VGND VGND VPWR VPWR _1766_ _0190_ _0189_ Nand_gate
X_3177_ VGND VGND VPWR VPWR _2148_ _0115_ _0114_ Nand_gate
X_4295_ VGND VGND VPWR VPWR _1324_ _1323_ inverter
X_3315_ VGND VGND VPWR VPWR _0261_ _0264_ _0265_ Nor_gate
XPHY_59 VGND VGND VPWR VPWR sky130_fd_sc_hd__decap_3
XPHY_48 VGND VGND VPWR VPWR sky130_fd_sc_hd__decap_3
XPHY_37 VGND VGND VPWR VPWR sky130_fd_sc_hd__decap_3
XPHY_15 VGND VGND VPWR VPWR sky130_fd_sc_hd__decap_3
XPHY_26 VGND VGND VPWR VPWR sky130_fd_sc_hd__decap_3
XFILLER_0_44_272 VGND VGND VPWR VPWR sky130_fd_sc_hd__fill_2
XFILLER_0_8_174 VGND VGND VPWR VPWR sky130_fd_sc_hd__decap_8
XFILLER_0_42_209 VGND VGND VPWR VPWR sky130_fd_sc_hd__fill_1
XFILLER_0_27_228 VGND VGND VPWR VPWR sky130_fd_sc_hd__decap_3
X_3031_ _2133_ VGND VGND VPWR VPWR net97 sky130_fd_sc_hd__buf_1
X_3100_ VGND VGND VPWR VPWR _2069_ _0032_ _0031_ Nand_gate
Xoutput91 net91 VGND VGND VPWR VPWR result[2] sky130_fd_sc_hd__clkbuf_4
X_4080_ VGND VGND VPWR VPWR _1092_ _0973_ inverter
Xoutput80 net80 VGND VGND VPWR VPWR result[1] sky130_fd_sc_hd__clkbuf_4
XFILLER_0_58_331 VGND VGND VPWR VPWR sky130_fd_sc_hd__fill_1
X_3933_ VGND VGND VPWR VPWR _0333_ _0933_ net16 Nand_gate
XFILLER_0_18_206 VGND VGND VPWR VPWR sky130_fd_sc_hd__decap_4
X_2746_ VGND VGND VPWR VPWR _1853_ _1664_ _1666_ _1588_ Mux
X_2815_ VGND VGND VPWR VPWR net36 _1920_ _1921_ Nor_gate
XFILLER_0_5_122 VGND VGND VPWR VPWR sky130_fd_sc_hd__fill_1
XFILLER_0_5_144 VGND VGND VPWR VPWR sky130_fd_sc_hd__decap_8
X_3795_ VGND VGND VPWR VPWR _0781_ _0784_ _0783_ Nand_gate
X_3864_ VGND VGND VPWR VPWR _0855_ _0858_ _0859_ Nor_gate
X_2677_ VGND VGND VPWR VPWR _1592_ _1681_ _1785_ Nor_gate
X_4347_ VGND VGND VPWR VPWR _1809_ _1379_ _1888_ Nand_gate
XTAP_150 VGND VPWR sky130_fd_sc_hd__tapvpwrvgnd_1
X_4278_ VGND VGND VPWR VPWR _1306_ _1108_ _1304_ _0379_ Mux
XTAP_161 VGND VPWR sky130_fd_sc_hd__tapvpwrvgnd_1
XTAP_172 VGND VPWR sky130_fd_sc_hd__tapvpwrvgnd_1
XTAP_183 VGND VPWR sky130_fd_sc_hd__tapvpwrvgnd_1
X_3229_ VGND VGND VPWR VPWR _1898_ _0171_ _0172_ Nor_gate
XTAP_194 VGND VPWR sky130_fd_sc_hd__tapvpwrvgnd_1
XFILLER_0_24_209 VGND VGND VPWR VPWR sky130_fd_sc_hd__fill_1
XFILLER_0_32_264 VGND VGND VPWR VPWR sky130_fd_sc_hd__fill_2
XFILLER_0_32_253 VGND VGND VPWR VPWR sky130_fd_sc_hd__decap_4
XFILLER_0_55_301 VPWR VGND VPWR VGND sky130_ef_sc_hd__decap_12
XFILLER_0_55_345 VGND VGND VPWR VPWR sky130_fd_sc_hd__fill_2
X_2600_ VGND VGND VPWR VPWR _1688_ _1709_ _1708_ Nand_gate
X_3580_ VGND VGND VPWR VPWR _0535_ _0552_ _0551_ Nand_gate
XFILLER_0_15_209 VGND VGND VPWR VPWR sky130_fd_sc_hd__decap_8
X_2531_ VGND VGND VPWR VPWR _1635_ _1640_ _1639_ Nand_gate
X_4201_ VGND VGND VPWR VPWR _0519_ _1222_ _1223_ Nor_gate
X_2462_ VGND VGND VPWR VPWR _1570_ _1571_ net57 Nand_gate
XFILLER_0_2_158 VGND VGND VPWR VPWR sky130_fd_sc_hd__decap_3
X_2393_ VGND VGND VPWR VPWR _1502_ _1501_ inverter
X_3014_ VGND VGND VPWR VPWR _1644_ _2116_ _2117_ Nor_gate
X_4132_ VGND VGND VPWR VPWR _0934_ _1148_ _1147_ Nand_gate
X_4063_ VGND VGND VPWR VPWR _1049_ _1074_ _1073_ Nand_gate
X_3916_ VGND VGND VPWR VPWR _0910_ _0915_ _0914_ Nand_gate
X_2729_ VGND VGND VPWR VPWR _1836_ _1834_ _1835_ _1712_ Mux
X_3847_ VGND VGND VPWR VPWR _0040_ _0113_ _0840_ Nor_gate
X_3778_ VGND VGND VPWR VPWR _0452_ _0764_ _0766_ Nor_gate
XFILLER_0_14_253 VPWR VGND VPWR VGND sky130_ef_sc_hd__decap_12
XFILLER_0_37_345 VGND VGND VPWR VPWR sky130_fd_sc_hd__fill_2
XFILLER_0_9_291 VGND VGND VPWR VPWR sky130_fd_sc_hd__decap_3
XFILLER_0_34_89 VGND VGND VPWR VPWR sky130_fd_sc_hd__fill_1
XFILLER_0_43_337 VGND VGND VPWR VPWR sky130_fd_sc_hd__decap_8
X_3632_ VGND VGND VPWR VPWR _0744_ _0607_ _0608_ Nor_gate
X_3563_ VGND VGND VPWR VPWR _0532_ _0533_ _0481_ Nand_gate
X_3701_ VGND VGND VPWR VPWR _0679_ _0681_ _0683_ Nor_gate
X_2445_ VGND VGND VPWR VPWR _0278_ _1554_ _1553_ Nand_gate
X_2514_ VGND VGND VPWR VPWR _1613_ _1622_ _1623_ Nor_gate
X_3494_ VGND VGND VPWR VPWR _0457_ _0458_ _0459_ Nor_gate
X_4115_ VGND VGND VPWR VPWR _1116_ _1130_ _1129_ Nand_gate
XFILLER_0_11_245 VGND VGND VPWR VPWR sky130_fd_sc_hd__fill_1
X_2376_ VGND VGND VPWR VPWR _1472_ _1484_ _1485_ Nor_gate
X_4046_ VGND VGND VPWR VPWR _1055_ _1054_ inverter
XFILLER_0_52_167 VGND VGND VPWR VPWR sky130_fd_sc_hd__fill_1
X_2230_ net10 VGND VGND VPWR VPWR _0679_ sky130_fd_sc_hd__clkbuf_4
XFILLER_0_45_55 VGND VGND VPWR VPWR sky130_fd_sc_hd__fill_1
XFILLER_0_0_13 VGND VGND VPWR VPWR sky130_fd_sc_hd__decap_4
XFILLER_0_17_9 VPWR VGND VPWR VGND sky130_ef_sc_hd__decap_12
X_2994_ VGND VGND VPWR VPWR _2097_ _1821_ _1828_ _1712_ Mux
XFILLER_0_28_197 VGND VGND VPWR VPWR sky130_fd_sc_hd__fill_2
XFILLER_0_0_35 VGND VGND VPWR VPWR sky130_fd_sc_hd__decap_8
XFILLER_0_9_33 VPWR VGND VPWR VGND sky130_ef_sc_hd__decap_12
XFILLER_0_16_326 VPWR VGND VPWR VGND sky130_ef_sc_hd__decap_12
X_3615_ VGND VGND VPWR VPWR _0584_ _0589_ _0590_ Nor_gate
XFILLER_0_3_297 VPWR VGND VPWR VGND sky130_ef_sc_hd__decap_12
XFILLER_0_3_275 VGND VGND VPWR VPWR sky130_fd_sc_hd__fill_1
X_3546_ VGND VGND VPWR VPWR _0511_ _0514_ _0515_ Nor_gate
XFILLER_0_50_3 VPWR VGND VPWR VGND sky130_ef_sc_hd__decap_12
X_2359_ VGND VGND VPWR VPWR _1449_ _1467_ _1468_ Nor_gate
X_3477_ VGND VGND VPWR VPWR _0269_ _0440_ _0439_ Nand_gate
X_2428_ VGND VGND VPWR VPWR _0376_ _1536_ _1537_ Nor_gate
X_4029_ VGND VGND VPWR VPWR _1034_ _1036_ _1037_ Nor_gate
XFILLER_0_22_307 VGND VGND VPWR VPWR sky130_fd_sc_hd__fill_1
XFILLER_0_31_57 VGND VGND VPWR VPWR sky130_fd_sc_hd__fill_2
XFILLER_0_40_126 VGND VGND VPWR VPWR sky130_fd_sc_hd__fill_2
XFILLER_0_0_223 VGND VGND VPWR VPWR sky130_fd_sc_hd__fill_1
X_3400_ VGND VGND VPWR VPWR _1813_ _0356_ _0357_ Nor_gate
X_3331_ VGND VGND VPWR VPWR _0033_ _0282_ _0281_ Nand_gate
XFILLER_0_56_65 VPWR VGND VPWR VGND sky130_ef_sc_hd__decap_12
X_3193_ VGND VGND VPWR VPWR _0125_ _0133_ _0132_ Nand_gate
X_3262_ VGND VGND VPWR VPWR _0204_ _0207_ _0208_ Nor_gate
XFILLER_0_0_289 VGND VGND VPWR VPWR sky130_fd_sc_hd__decap_8
X_2213_ VGND VGND VPWR VPWR _0463_ _0484_ _0495_ Nor_gate
XFILLER_0_22_7 VGND VGND VPWR VPWR sky130_fd_sc_hd__fill_2
XFILLER_0_8_301 VGND VGND VPWR VPWR sky130_fd_sc_hd__decap_6
X_2977_ VGND VGND VPWR VPWR _2080_ _1816_ inverter
XFILLER_0_8_345 VGND VGND VPWR VPWR sky130_fd_sc_hd__fill_2
XFILLER_0_16_156 VGND VGND VPWR VPWR sky130_fd_sc_hd__fill_2
X_3529_ VGND VGND VPWR VPWR _0497_ _2161_ inverter
XFILLER_0_54_218 VGND VGND VPWR VPWR sky130_fd_sc_hd__decap_3
X_2900_ VGND VGND VPWR VPWR _2005_ _1612_ _1629_ _1713_ Mux
XFILLER_0_53_273 VGND VGND VPWR VPWR sky130_fd_sc_hd__decap_6
X_2831_ VGND VGND VPWR VPWR _1937_ _1936_ inverter
XFILLER_0_42_78 VGND VGND VPWR VPWR sky130_fd_sc_hd__decap_6
X_2762_ VGND VGND VPWR VPWR _1863_ _1869_ _1868_ Nand_gate
XFILLER_0_38_292 VGND VGND VPWR VPWR sky130_fd_sc_hd__decap_6
X_3880_ VGND VGND VPWR VPWR _0874_ _0876_ _0875_ Nand_gate
XFILLER_0_5_337 VGND VGND VPWR VPWR sky130_fd_sc_hd__decap_8
XTAP_332 VGND VPWR sky130_fd_sc_hd__tapvpwrvgnd_1
XTAP_321 VGND VPWR sky130_fd_sc_hd__tapvpwrvgnd_1
XTAP_310 VGND VPWR sky130_fd_sc_hd__tapvpwrvgnd_1
X_2693_ VGND VGND VPWR VPWR net12 _1801_ _1800_ Nand_gate
X_4294_ VGND VGND VPWR VPWR _1319_ _1322_ _1323_ Nor_gate
X_4363_ VGND VGND VPWR VPWR _0756_ _1397_ _1396_ Nand_gate
X_3314_ VGND VGND VPWR VPWR _1262_ _0263_ _0264_ Nor_gate
XTAP_398 VGND VPWR sky130_fd_sc_hd__tapvpwrvgnd_1
XTAP_387 VGND VPWR sky130_fd_sc_hd__tapvpwrvgnd_1
XTAP_376 VGND VPWR sky130_fd_sc_hd__tapvpwrvgnd_1
XTAP_365 VGND VPWR sky130_fd_sc_hd__tapvpwrvgnd_1
XTAP_354 VGND VPWR sky130_fd_sc_hd__tapvpwrvgnd_1
XTAP_343 VGND VPWR sky130_fd_sc_hd__tapvpwrvgnd_1
X_3176_ VGND VGND VPWR VPWR _1614_ _0114_ _1771_ Nand_gate
X_3245_ VGND VGND VPWR VPWR _0185_ _0189_ _0188_ Nand_gate
XFILLER_0_13_3 VPWR VGND VPWR VGND sky130_ef_sc_hd__decap_12
XPHY_49 VGND VGND VPWR VPWR sky130_fd_sc_hd__decap_3
XPHY_38 VGND VGND VPWR VPWR sky130_fd_sc_hd__decap_3
XPHY_16 VGND VGND VPWR VPWR sky130_fd_sc_hd__decap_3
XFILLER_0_8_120 VGND VGND VPWR VPWR sky130_fd_sc_hd__fill_2
XFILLER_0_8_131 VGND VGND VPWR VPWR sky130_fd_sc_hd__decap_6
XPHY_27 VGND VGND VPWR VPWR sky130_fd_sc_hd__decap_3
XFILLER_0_8_186 VGND VGND VPWR VPWR sky130_fd_sc_hd__decap_8
XFILLER_0_8_197 VGND VGND VPWR VPWR sky130_fd_sc_hd__decap_8
XFILLER_0_12_15 VPWR VGND VPWR VGND sky130_ef_sc_hd__decap_12
XFILLER_0_50_210 VGND VGND VPWR VPWR sky130_fd_sc_hd__decap_6
Xoutput70 net70 VGND VGND VPWR VPWR result[10] sky130_fd_sc_hd__clkbuf_4
XFILLER_0_37_78 VPWR VGND VPWR VGND sky130_ef_sc_hd__decap_12
Xoutput92 net92 VGND VGND VPWR VPWR result[30] sky130_fd_sc_hd__clkbuf_4
X_3030_ VGND VGND VPWR VPWR _2091_ _2133_ _2132_ Nand_gate
Xoutput81 net81 VGND VGND VPWR VPWR result[20] sky130_fd_sc_hd__clkbuf_4
XFILLER_0_53_66 VGND VGND VPWR VPWR sky130_fd_sc_hd__decap_4
XFILLER_0_53_44 VPWR VGND VPWR VGND sky130_ef_sc_hd__decap_12
X_3932_ VGND VGND VPWR VPWR _1658_ _0932_ _0892_ Nand_gate
X_3863_ VGND VGND VPWR VPWR _0398_ _0857_ _0858_ Nor_gate
XFILLER_0_41_254 VGND VGND VPWR VPWR sky130_fd_sc_hd__fill_1
X_2676_ VGND VGND VPWR VPWR _1781_ _1783_ _1784_ Nor_gate
X_2745_ VGND VGND VPWR VPWR _1831_ _1851_ _1852_ Nor_gate
X_2814_ VGND VGND VPWR VPWR net35 _1920_ _1919_ Nand_gate
X_3794_ VGND VGND VPWR VPWR _0552_ _0783_ _0782_ Nand_gate
X_4277_ VGND VGND VPWR VPWR _1304_ _1214_ _1303_ _0255_ Mux
XTAP_151 VGND VPWR sky130_fd_sc_hd__tapvpwrvgnd_1
XTAP_140 VGND VPWR sky130_fd_sc_hd__tapvpwrvgnd_1
XTAP_162 VGND VPWR sky130_fd_sc_hd__tapvpwrvgnd_1
XTAP_173 VGND VPWR sky130_fd_sc_hd__tapvpwrvgnd_1
XTAP_184 VGND VPWR sky130_fd_sc_hd__tapvpwrvgnd_1
X_4346_ VGND VGND VPWR VPWR _1375_ _1377_ _1378_ Nor_gate
X_3159_ VGND VGND VPWR VPWR _0093_ _0095_ _0096_ Nor_gate
X_3228_ VGND VGND VPWR VPWR _0156_ _0168_ _0171_ Nor_gate
XTAP_195 VGND VPWR sky130_fd_sc_hd__tapvpwrvgnd_1
XFILLER_0_2_3 VPWR VGND VPWR VGND sky130_ef_sc_hd__decap_12
XFILLER_0_55_313 VPWR VGND VPWR VGND sky130_ef_sc_hd__decap_12
X_2530_ VGND VGND VPWR VPWR _1636_ _1638_ _1639_ Nor_gate
XFILLER_0_23_232 VGND VGND VPWR VPWR sky130_fd_sc_hd__fill_1
XFILLER_0_23_221 VGND VGND VPWR VPWR sky130_fd_sc_hd__decap_3
X_2461_ VGND VGND VPWR VPWR _1570_ net21 inverter
X_4131_ VGND VGND VPWR VPWR _1147_ _1042_ inverter
X_4200_ VGND VGND VPWR VPWR _0228_ _0346_ _1222_ Nor_gate
X_2392_ VGND VGND VPWR VPWR _1488_ _1500_ _1501_ Nor_gate
X_3013_ VGND VGND VPWR VPWR _2107_ _2115_ _2116_ Nor_gate
X_4062_ VGND VGND VPWR VPWR _1061_ _1072_ _1073_ Nor_gate
XFILLER_0_3_57 VPWR VGND VPWR VGND sky130_ef_sc_hd__decap_12
XFILLER_0_58_195 VGND VGND VPWR VPWR sky130_fd_sc_hd__fill_1
X_3846_ VGND VGND VPWR VPWR _0834_ _0838_ _0839_ Nor_gate
X_3915_ VGND VGND VPWR VPWR _0914_ _0913_ inverter
X_2659_ VGND VGND VPWR VPWR _1767_ _1750_ inverter
X_2728_ VGND VGND VPWR VPWR _1835_ _1659_ _1663_ _1588_ Mux
X_3777_ VGND VGND VPWR VPWR _0764_ _0762_ inverter
XFILLER_0_14_265 VGND VGND VPWR VPWR sky130_fd_sc_hd__fill_1
X_4329_ VGND VGND VPWR VPWR _0029_ _1684_ _1361_ Nor_gate
XFILLER_0_1_181 VPWR VGND VPWR VGND sky130_ef_sc_hd__decap_12
XFILLER_0_49_162 VGND VGND VPWR VPWR sky130_fd_sc_hd__decap_3
XFILLER_0_49_195 VGND VGND VPWR VPWR sky130_fd_sc_hd__decap_4
XFILLER_0_20_279 VPWR VGND VPWR VGND sky130_ef_sc_hd__decap_12
XFILLER_0_18_36 VGND VGND VPWR VPWR sky130_fd_sc_hd__decap_8
XFILLER_0_18_47 VGND VGND VPWR VPWR sky130_fd_sc_hd__decap_6
XFILLER_0_43_305 VGND VGND VPWR VPWR sky130_fd_sc_hd__fill_1
XFILLER_0_34_68 VGND VGND VPWR VPWR sky130_fd_sc_hd__decap_3
XFILLER_0_28_346 VGND VGND VPWR VPWR sky130_fd_sc_hd__fill_1
X_3700_ VGND VGND VPWR VPWR _0679_ _0682_ _0681_ Nand_gate
X_3493_ VGND VGND VPWR VPWR _1625_ _2100_ _0458_ Nor_gate
X_2513_ VGND VGND VPWR VPWR _1614_ _1622_ _1621_ Nand_gate
X_3631_ VGND VGND VPWR VPWR _0607_ _0606_ inverter
X_3562_ VGND VGND VPWR VPWR _0532_ _0421_ inverter
X_2444_ VGND VGND VPWR VPWR _1549_ _1553_ _1552_ Nand_gate
X_4114_ VGND VGND VPWR VPWR _1118_ _1128_ _1129_ Nor_gate
X_2375_ VGND VGND VPWR VPWR _1273_ _1483_ _1484_ Nor_gate
X_4045_ VGND VGND VPWR VPWR _1054_ _0845_ _1053_ _1870_ Mux
XFILLER_0_6_273 VPWR VGND VPWR VGND sky130_ef_sc_hd__decap_12
X_3829_ VPWR VGND VGND VPWR net50 _0821_ _0820_ Xnor
XFILLER_0_52_102 VPWR VGND VPWR VGND sky130_ef_sc_hd__decap_12
XFILLER_0_37_121 VGND VGND VPWR VPWR sky130_fd_sc_hd__fill_1
XFILLER_0_20_59 VPWR VGND VPWR VGND sky130_ef_sc_hd__decap_12
XFILLER_0_20_37 VGND VGND VPWR VPWR sky130_fd_sc_hd__decap_4
XFILLER_0_29_57 VPWR VGND VPWR VGND sky130_ef_sc_hd__decap_12
XFILLER_0_29_24 VPWR VGND VPWR VGND sky130_ef_sc_hd__decap_12
XFILLER_0_43_113 VGND VGND VPWR VPWR sky130_fd_sc_hd__decap_8
X_2993_ VGND VGND VPWR VPWR _2011_ _2095_ _2096_ Nor_gate
X_3614_ VGND VGND VPWR VPWR _0586_ _0588_ _0589_ Nor_gate
XFILLER_0_9_45 VGND VGND VPWR VPWR sky130_fd_sc_hd__decap_4
XFILLER_0_16_338 VGND VGND VPWR VPWR sky130_fd_sc_hd__decap_4
X_3476_ VGND VGND VPWR VPWR _0852_ _0439_ _0437_ Nand_gate
X_2427_ VGND VGND VPWR VPWR _1532_ _1535_ _1536_ Nor_gate
X_3545_ VGND VGND VPWR VPWR _0514_ _0512_ _0513_ _1025_ Mux
XFILLER_0_43_3 VPWR VGND VPWR VGND sky130_ef_sc_hd__decap_12
X_4028_ VGND VGND VPWR VPWR _0979_ _1036_ _0984_ Nand_gate
X_2358_ VGND VGND VPWR VPWR _1452_ _1466_ _1467_ Nor_gate
X_2289_ net30 VGND VGND VPWR VPWR _1316_ sky130_fd_sc_hd__clkbuf_4
XFILLER_0_19_154 VGND VGND VPWR VPWR sky130_fd_sc_hd__fill_1
XFILLER_0_34_113 VGND VGND VPWR VPWR sky130_fd_sc_hd__fill_1
XFILLER_0_15_15 VGND VGND VPWR VPWR sky130_fd_sc_hd__decap_8
XFILLER_0_25_113 VGND VGND VPWR VPWR sky130_fd_sc_hd__fill_2
XFILLER_0_40_138 VGND VGND VPWR VPWR sky130_fd_sc_hd__fill_2
XFILLER_0_25_179 VGND VGND VPWR VPWR sky130_fd_sc_hd__decap_8
XFILLER_0_0_279 VGND VGND VPWR VPWR sky130_fd_sc_hd__fill_1
X_3330_ VGND VGND VPWR VPWR _0281_ _0280_ inverter
XFILLER_0_56_77 VGND VGND VPWR VPWR sky130_fd_sc_hd__decap_6
X_3192_ VGND VGND VPWR VPWR _0132_ _0131_ inverter
X_3261_ VGND VGND VPWR VPWR _1186_ _0206_ _0207_ Nor_gate
X_2212_ VGND VGND VPWR VPWR _0484_ _0474_ inverter
XFILLER_0_56_271 VPWR VGND VPWR VGND sky130_ef_sc_hd__decap_12
XFILLER_0_31_105 VGND VGND VPWR VPWR sky130_fd_sc_hd__fill_1
X_2976_ VGND VGND VPWR VPWR _2076_ _2078_ _2079_ Nor_gate
XFILLER_0_24_190 VGND VGND VPWR VPWR sky130_fd_sc_hd__decap_6
XFILLER_0_16_168 VGND VGND VPWR VPWR sky130_fd_sc_hd__fill_1
X_3459_ VPWR VGND VGND VPWR _0852_ _0421_ _0420_ Xnor
X_3528_ VGND VGND VPWR VPWR _0492_ _0494_ _0496_ Nor_gate
XFILLER_0_30_193 VGND VGND VPWR VPWR sky130_fd_sc_hd__decap_3
X_2830_ VGND VGND VPWR VPWR _1936_ _1420_ _1428_ _1607_ Mux
XFILLER_0_45_208 VGND VGND VPWR VPWR sky130_fd_sc_hd__fill_1
XANTENNA_1 net70 VGND VGND VPWR VPWR sky130_fd_sc_hd__diode_2
X_2761_ VGND VGND VPWR VPWR _1637_ _1867_ _1868_ Nor_gate
X_2692_ VGND VGND VPWR VPWR _1764_ _1680_ _1800_ Nor_gate
XFILLER_0_13_138 VPWR VGND VPWR VGND sky130_ef_sc_hd__decap_12
XTAP_366 VGND VPWR sky130_fd_sc_hd__tapvpwrvgnd_1
XTAP_355 VGND VPWR sky130_fd_sc_hd__tapvpwrvgnd_1
XTAP_344 VGND VPWR sky130_fd_sc_hd__tapvpwrvgnd_1
XTAP_333 VGND VPWR sky130_fd_sc_hd__tapvpwrvgnd_1
X_3244_ VGND VGND VPWR VPWR _1650_ _0188_ _0187_ Nand_gate
XTAP_322 VGND VPWR sky130_fd_sc_hd__tapvpwrvgnd_1
XTAP_311 VGND VPWR sky130_fd_sc_hd__tapvpwrvgnd_1
XTAP_300 VGND VPWR sky130_fd_sc_hd__tapvpwrvgnd_1
X_4293_ VGND VGND VPWR VPWR _1320_ _1322_ _1321_ Nand_gate
X_3313_ VGND VGND VPWR VPWR _1682_ _0262_ _0263_ Nor_gate
X_4362_ VGND VGND VPWR VPWR net85 _1395_ _1396_ Nor_gate
XTAP_399 VGND VPWR sky130_fd_sc_hd__tapvpwrvgnd_1
XTAP_388 VGND VPWR sky130_fd_sc_hd__tapvpwrvgnd_1
XTAP_377 VGND VPWR sky130_fd_sc_hd__tapvpwrvgnd_1
X_3175_ _1644_ VGND VGND VPWR VPWR _0113_ sky130_fd_sc_hd__buf_2
XPHY_17 VGND VGND VPWR VPWR sky130_fd_sc_hd__decap_3
XPHY_28 VGND VGND VPWR VPWR sky130_fd_sc_hd__decap_3
XFILLER_0_29_271 VGND VGND VPWR VPWR sky130_fd_sc_hd__decap_3
X_2959_ VGND VGND VPWR VPWR _2060_ _2063_ _2062_ Nand_gate
XPHY_39 VGND VGND VPWR VPWR sky130_fd_sc_hd__decap_3
XFILLER_0_50_233 VGND VGND VPWR VPWR sky130_fd_sc_hd__decap_6
XFILLER_0_35_296 VGND VGND VPWR VPWR sky130_fd_sc_hd__decap_3
XFILLER_0_12_27 VGND VGND VPWR VPWR sky130_fd_sc_hd__fill_1
XFILLER_0_12_49 VGND VGND VPWR VPWR sky130_fd_sc_hd__fill_2
Xoutput82 net82 VGND VGND VPWR VPWR result[21] sky130_fd_sc_hd__clkbuf_4
Xoutput71 net71 VGND VGND VPWR VPWR result[11] sky130_fd_sc_hd__clkbuf_4
XFILLER_0_37_24 VGND VGND VPWR VPWR sky130_fd_sc_hd__fill_2
Xoutput93 net93 VGND VGND VPWR VPWR result[31] sky130_fd_sc_hd__clkbuf_4
XFILLER_0_10_119 VGND VGND VPWR VPWR sky130_fd_sc_hd__fill_1
XFILLER_0_37_57 VPWR VGND VPWR VGND sky130_ef_sc_hd__decap_12
XFILLER_0_37_35 VPWR VGND VPWR VGND sky130_ef_sc_hd__decap_12
X_2813_ VGND VGND VPWR VPWR _1678_ _1691_ _1919_ Nor_gate
XFILLER_0_18_219 VPWR VGND VPWR VGND sky130_ef_sc_hd__decap_12
X_3931_ VGND VGND VPWR VPWR _0928_ _0930_ _0931_ Nor_gate
X_3862_ VGND VGND VPWR VPWR _0511_ _0856_ _0857_ Nor_gate
XFILLER_0_41_211 VGND VGND VPWR VPWR sky130_fd_sc_hd__fill_1
X_2675_ VGND VGND VPWR VPWR _1690_ _1783_ _1782_ Nand_gate
X_2744_ VGND VGND VPWR VPWR _1700_ _1851_ _1827_ Nand_gate
X_3793_ VGND VGND VPWR VPWR _0672_ _0773_ _0782_ Nor_gate
XFILLER_0_5_113 VGND VGND VPWR VPWR sky130_fd_sc_hd__fill_1
XFILLER_0_5_179 VPWR VGND VPWR VGND sky130_ef_sc_hd__decap_12
X_4276_ VGND VGND VPWR VPWR _1303_ net24 _1565_ _1676_ Mux
XTAP_152 VGND VPWR sky130_fd_sc_hd__tapvpwrvgnd_1
XTAP_141 VGND VPWR sky130_fd_sc_hd__tapvpwrvgnd_1
XTAP_130 VGND VPWR sky130_fd_sc_hd__tapvpwrvgnd_1
XTAP_163 VGND VPWR sky130_fd_sc_hd__tapvpwrvgnd_1
XTAP_174 VGND VPWR sky130_fd_sc_hd__tapvpwrvgnd_1
X_3227_ VGND VGND VPWR VPWR _0156_ _0169_ _0168_ Nand_gate
XTAP_185 VGND VPWR sky130_fd_sc_hd__tapvpwrvgnd_1
XTAP_196 VGND VPWR sky130_fd_sc_hd__tapvpwrvgnd_1
X_4345_ VGND VGND VPWR VPWR _1377_ _1376_ inverter
XFILLER_0_49_311 VPWR VGND VPWR VGND sky130_ef_sc_hd__decap_12
X_3089_ VGND VGND VPWR VPWR _0017_ _0020_ _0019_ Nand_gate
X_3158_ VGND VGND VPWR VPWR _1475_ _0091_ _0095_ Nor_gate
XFILLER_0_55_325 VGND VGND VPWR VPWR sky130_fd_sc_hd__decap_8
XFILLER_0_23_299 VGND VGND VPWR VPWR sky130_fd_sc_hd__fill_1
X_2460_ VGND VGND VPWR VPWR _1567_ _1568_ _1569_ Nor_gate
XFILLER_0_48_56 VPWR VGND VPWR VGND sky130_ef_sc_hd__decap_12
X_4130_ VGND VGND VPWR VPWR _1544_ _1146_ _1103_ Nand_gate
X_4061_ VGND VGND VPWR VPWR _1062_ _1072_ _1071_ Nand_gate
X_2391_ VGND VGND VPWR VPWR _1057_ _1499_ _1500_ Nor_gate
XFILLER_0_58_141 VGND VGND VPWR VPWR sky130_fd_sc_hd__fill_2
X_3012_ VGND VGND VPWR VPWR _1997_ _2115_ _2114_ Nand_gate
XFILLER_0_3_69 VPWR VGND VPWR VGND sky130_ef_sc_hd__decap_12
X_3776_ VGND VGND VPWR VPWR _1533_ _0762_ _0763_ Nor_gate
X_3845_ VGND VGND VPWR VPWR _0269_ _0838_ _0837_ Nand_gate
X_3914_ VGND VGND VPWR VPWR _0344_ _0912_ _0913_ Nor_gate
X_2727_ VGND VGND VPWR VPWR _1834_ _1653_ _1656_ _1628_ Mux
X_2589_ VGND VGND VPWR VPWR _1438_ net62 _1698_ Nor_gate
X_2658_ _1765_ VGND VGND VPWR VPWR _1766_ sky130_fd_sc_hd__clkbuf_4
XFILLER_0_1_193 VPWR VGND VPWR VGND sky130_ef_sc_hd__decap_12
X_4259_ VGND VGND VPWR VPWR _0181_ _0355_ _1285_ Nor_gate
X_4328_ VGND VGND VPWR VPWR _1358_ _1880_ _1360_ Nor_gate
XFILLER_0_49_185 VGND VGND VPWR VPWR sky130_fd_sc_hd__fill_1
XFILLER_0_49_130 VGND VGND VPWR VPWR sky130_fd_sc_hd__fill_1
XFILLER_0_37_325 VGND VGND VPWR VPWR sky130_fd_sc_hd__fill_2
XFILLER_0_20_214 VPWR VGND VPWR VGND sky130_ef_sc_hd__decap_12
XFILLER_0_9_271 VGND VGND VPWR VPWR sky130_fd_sc_hd__decap_8
XFILLER_0_20_236 VGND VGND VPWR VPWR sky130_fd_sc_hd__decap_8
XFILLER_0_34_36 VPWR VGND VPWR VGND sky130_ef_sc_hd__decap_12
XFILLER_0_55_122 VGND VGND VPWR VPWR sky130_fd_sc_hd__decap_6
XFILLER_0_50_79 VGND VGND VPWR VPWR sky130_fd_sc_hd__decap_4
XFILLER_0_28_325 VGND VGND VPWR VPWR sky130_fd_sc_hd__fill_2
XFILLER_0_28_303 VGND VGND VPWR VPWR sky130_fd_sc_hd__fill_1
X_3630_ VPWR VGND VGND VPWR net45 _0606_ _0605_ Xnor
X_2512_ VGND VGND VPWR VPWR _1606_ _1621_ _1620_ Nand_gate
X_3492_ VGND VGND VPWR VPWR _0457_ _0456_ inverter
X_2443_ VGND VGND VPWR VPWR _0246_ _1552_ _1551_ Nand_gate
X_3561_ VGND VGND VPWR VPWR _0165_ _0530_ _0531_ Nor_gate
XFILLER_0_11_225 VGND VGND VPWR VPWR sky130_fd_sc_hd__decap_8
X_4044_ VGND VGND VPWR VPWR _1053_ _0940_ _1052_ _2155_ Mux
X_4113_ VGND VGND VPWR VPWR _1119_ _1128_ _1127_ Nand_gate
X_2374_ VGND VGND VPWR VPWR _1474_ _1482_ _1483_ Nor_gate
XFILLER_0_46_166 VGND VGND VPWR VPWR sky130_fd_sc_hd__fill_1
XFILLER_0_34_317 VGND VGND VPWR VPWR sky130_fd_sc_hd__fill_1
X_3759_ VGND VGND VPWR VPWR _0511_ _0745_ _0746_ Nor_gate
XFILLER_0_6_285 VPWR VGND VPWR VGND sky130_ef_sc_hd__decap_12
X_3828_ VGND VGND VPWR VPWR _0761_ _0820_ _0818_ Nand_gate
XFILLER_0_10_291 VGND VGND VPWR VPWR sky130_fd_sc_hd__fill_1
XFILLER_0_52_125 VGND VGND VPWR VPWR sky130_fd_sc_hd__fill_2
XFILLER_0_52_114 VGND VGND VPWR VPWR sky130_fd_sc_hd__fill_2
XFILLER_0_37_166 VGND VGND VPWR VPWR sky130_fd_sc_hd__fill_2
XFILLER_0_37_100 VGND VGND VPWR VPWR sky130_fd_sc_hd__fill_1
XFILLER_0_20_16 VPWR VGND VPWR VGND sky130_ef_sc_hd__decap_12
XFILLER_0_29_69 VGND VGND VPWR VPWR sky130_fd_sc_hd__fill_1
XFILLER_0_29_36 VPWR VGND VPWR VGND sky130_ef_sc_hd__decap_12
X_2992_ VGND VGND VPWR VPWR _2095_ _1867_ _2094_ _1605_ Mux
XFILLER_0_45_57 VGND VGND VPWR VPWR sky130_fd_sc_hd__decap_4
XFILLER_0_28_111 VPWR VGND VPWR VGND sky130_ef_sc_hd__decap_12
X_3613_ VGND VGND VPWR VPWR _1880_ _0588_ _0587_ Nand_gate
XFILLER_0_3_222 VGND VGND VPWR VPWR sky130_fd_sc_hd__fill_2
XFILLER_0_9_57 VGND VGND VPWR VPWR sky130_fd_sc_hd__fill_2
XFILLER_0_51_180 VGND VGND VPWR VPWR sky130_fd_sc_hd__fill_1
X_3544_ _1693_ VGND VGND VPWR VPWR _0513_ sky130_fd_sc_hd__buf_2
X_3475_ VGND VGND VPWR VPWR _0852_ _0437_ _0438_ Nor_gate
XFILLER_0_10_93 VGND VGND VPWR VPWR sky130_fd_sc_hd__decap_4
X_2426_ VGND VGND VPWR VPWR _0430_ _1534_ _1535_ Nor_gate
X_4027_ VGND VGND VPWR VPWR _1032_ _1033_ _1034_ Nor_gate
X_2357_ VGND VGND VPWR VPWR _1453_ _1465_ _1466_ Nor_gate
X_2288_ VGND VGND VPWR VPWR _1078_ _1294_ _1305_ Nor_gate
XFILLER_0_35_90 VGND VGND VPWR VPWR sky130_fd_sc_hd__fill_2
XFILLER_0_22_309 VPWR VGND VPWR VGND sky130_ef_sc_hd__decap_12
XFILLER_0_15_27 VPWR VGND VPWR VGND sky130_ef_sc_hd__decap_12
XFILLER_0_31_15 VPWR VGND VPWR VGND sky130_ef_sc_hd__decap_12
XFILLER_0_25_158 VGND VGND VPWR VPWR sky130_fd_sc_hd__fill_1
XFILLER_0_25_125 VGND VGND VPWR VPWR sky130_fd_sc_hd__decap_6
XFILLER_0_21_320 VGND VGND VPWR VPWR sky130_fd_sc_hd__decap_4
X_3260_ VGND VGND VPWR VPWR _1681_ _0205_ _0206_ Nor_gate
XFILLER_0_0_247 VGND VGND VPWR VPWR sky130_fd_sc_hd__decap_4
XFILLER_0_0_225 VGND VGND VPWR VPWR sky130_fd_sc_hd__fill_2
X_3191_ VGND VGND VPWR VPWR _1089_ _0130_ _0131_ Nor_gate
X_2211_ VGND VGND VPWR VPWR _0452_ _0474_ net49 Nand_gate
XFILLER_0_56_283 VPWR VGND VPWR VGND sky130_ef_sc_hd__decap_12
XFILLER_0_48_217 VGND VGND VPWR VPWR sky130_fd_sc_hd__decap_3
X_2975_ VGND VGND VPWR VPWR _1970_ _2077_ _2078_ Nor_gate
X_3527_ VGND VGND VPWR VPWR _0269_ _0494_ _0493_ Nand_gate
X_3389_ VGND VGND VPWR VPWR _0313_ _0345_ _0346_ Nor_gate
X_3458_ VPWR VGND VGND VPWR net42 _0420_ _0418_ Xnor
X_2409_ VGND VGND VPWR VPWR _1518_ net8 inverter
XFILLER_0_47_294 VGND VGND VPWR VPWR sky130_fd_sc_hd__fill_1
XFILLER_0_47_261 VGND VGND VPWR VPWR sky130_fd_sc_hd__fill_2
XFILLER_0_22_106 VGND VGND VPWR VPWR sky130_fd_sc_hd__decap_3
XFILLER_0_26_48 VGND VGND VPWR VPWR sky130_fd_sc_hd__fill_1
XFILLER_0_38_250 VGND VGND VPWR VPWR sky130_fd_sc_hd__fill_2
XANTENNA_2 net95 VGND VGND VPWR VPWR sky130_fd_sc_hd__diode_2
XFILLER_0_53_220 VGND VGND VPWR VPWR sky130_fd_sc_hd__decap_4
X_2760_ VGND VGND VPWR VPWR _1867_ _1866_ inverter
X_2691_ VGND VGND VPWR VPWR _1703_ _1798_ _1799_ Nor_gate
XFILLER_0_5_328 VGND VGND VPWR VPWR sky130_fd_sc_hd__decap_8
XFILLER_0_13_128 VGND VGND VPWR VPWR sky130_fd_sc_hd__fill_1
XTAP_389 VGND VPWR sky130_fd_sc_hd__tapvpwrvgnd_1
XTAP_378 VGND VPWR sky130_fd_sc_hd__tapvpwrvgnd_1
XTAP_367 VGND VPWR sky130_fd_sc_hd__tapvpwrvgnd_1
XTAP_356 VGND VPWR sky130_fd_sc_hd__tapvpwrvgnd_1
XTAP_345 VGND VPWR sky130_fd_sc_hd__tapvpwrvgnd_1
XTAP_334 VGND VPWR sky130_fd_sc_hd__tapvpwrvgnd_1
X_3243_ VGND VGND VPWR VPWR _2148_ _0187_ _0186_ Nand_gate
XTAP_323 VGND VPWR sky130_fd_sc_hd__tapvpwrvgnd_1
XTAP_312 VGND VPWR sky130_fd_sc_hd__tapvpwrvgnd_1
XTAP_301 VGND VPWR sky130_fd_sc_hd__tapvpwrvgnd_1
X_4292_ VGND VGND VPWR VPWR net60 _1321_ _0393_ Nand_gate
XFILLER_0_21_194 VGND VGND VPWR VPWR sky130_fd_sc_hd__decap_6
X_3312_ VGND VGND VPWR VPWR _0262_ _1985_ _1984_ _1240_ Mux
X_4361_ VGND VGND VPWR VPWR _0713_ _1395_ _0817_ Nand_gate
X_3174_ VGND VGND VPWR VPWR _1922_ _0112_ _0111_ Nand_gate
XPHY_18 VGND VGND VPWR VPWR sky130_fd_sc_hd__decap_3
XPHY_29 VGND VGND VPWR VPWR sky130_fd_sc_hd__decap_3
XFILLER_0_44_264 VGND VGND VPWR VPWR sky130_fd_sc_hd__decap_8
XFILLER_0_44_253 VGND VGND VPWR VPWR sky130_fd_sc_hd__decap_4
X_2958_ VGND VGND VPWR VPWR _1791_ _2061_ _2062_ Nor_gate
XFILLER_0_8_111 VGND VGND VPWR VPWR sky130_fd_sc_hd__decap_3
X_2889_ VGND VGND VPWR VPWR _1669_ _1993_ _1994_ Nor_gate
XFILLER_0_12_194 VGND VGND VPWR VPWR sky130_fd_sc_hd__fill_2
XFILLER_0_50_223 VGND VGND VPWR VPWR sky130_fd_sc_hd__fill_1
XFILLER_0_35_231 VPWR VGND VPWR VGND sky130_ef_sc_hd__decap_12
XFILLER_0_2_309 VPWR VGND VPWR VGND sky130_ef_sc_hd__decap_12
Xoutput83 net83 VGND VGND VPWR VPWR result[22] sky130_fd_sc_hd__clkbuf_4
XFILLER_0_50_289 VPWR VGND VPWR VGND sky130_ef_sc_hd__decap_12
XFILLER_0_37_47 VGND VGND VPWR VPWR sky130_fd_sc_hd__decap_6
Xoutput72 net72 VGND VGND VPWR VPWR result[12] sky130_fd_sc_hd__clkbuf_4
Xoutput94 net94 VGND VGND VPWR VPWR result[3] sky130_fd_sc_hd__clkbuf_4
XFILLER_0_58_323 VGND VGND VPWR VPWR sky130_fd_sc_hd__fill_2
XFILLER_0_37_69 VGND VGND VPWR VPWR sky130_fd_sc_hd__decap_6
X_3930_ VGND VGND VPWR VPWR _0676_ _0930_ _0929_ Nand_gate
X_2743_ VGND VGND VPWR VPWR _1766_ _1850_ _1849_ Nand_gate
X_2812_ VGND VGND VPWR VPWR _1700_ _1917_ _1918_ Nor_gate
X_3792_ VGND VGND VPWR VPWR _0774_ _0780_ _0781_ Nor_gate
X_3861_ VGND VGND VPWR VPWR _0856_ _0512_ _0513_ _0409_ Mux
XFILLER_0_41_234 VPWR VGND VPWR VGND sky130_ef_sc_hd__decap_12
X_2674_ VGND VGND VPWR VPWR _1586_ _1782_ _1780_ Nand_gate
X_4344_ VGND VGND VPWR VPWR net70 net72 _1376_ Nor_gate
XFILLER_0_1_320 VPWR VGND VPWR VGND sky130_ef_sc_hd__decap_12
XFILLER_0_5_169 VGND VGND VPWR VPWR sky130_fd_sc_hd__decap_4
X_4275_ VGND VGND VPWR VPWR _1863_ _0455_ _1302_ Nor_gate
XTAP_153 VGND VPWR sky130_fd_sc_hd__tapvpwrvgnd_1
XTAP_142 VGND VPWR sky130_fd_sc_hd__tapvpwrvgnd_1
XTAP_120 VGND VPWR sky130_fd_sc_hd__tapvpwrvgnd_1
XTAP_131 VGND VPWR sky130_fd_sc_hd__tapvpwrvgnd_1
XTAP_164 VGND VPWR sky130_fd_sc_hd__tapvpwrvgnd_1
X_3226_ VGND VGND VPWR VPWR _0158_ _0167_ _0168_ Nor_gate
XTAP_175 VGND VPWR sky130_fd_sc_hd__tapvpwrvgnd_1
X_3157_ VGND VGND VPWR VPWR _0088_ _0092_ _0093_ Nor_gate
XTAP_186 VGND VPWR sky130_fd_sc_hd__tapvpwrvgnd_1
XTAP_197 VGND VPWR sky130_fd_sc_hd__tapvpwrvgnd_1
XFILLER_0_49_323 VPWR VGND VPWR VGND sky130_ef_sc_hd__decap_12
X_3088_ VGND VGND VPWR VPWR _1969_ _0019_ _0018_ Nand_gate
XFILLER_0_17_220 VGND VGND VPWR VPWR sky130_fd_sc_hd__decap_4
XFILLER_0_7_90 VGND VGND VPWR VPWR sky130_fd_sc_hd__fill_1
XFILLER_0_55_337 VGND VGND VPWR VPWR sky130_fd_sc_hd__decap_8
XFILLER_0_23_278 VGND VGND VPWR VPWR sky130_fd_sc_hd__fill_2
XFILLER_0_2_139 VGND VGND VPWR VPWR sky130_fd_sc_hd__fill_1
XFILLER_0_48_68 VGND VGND VPWR VPWR sky130_fd_sc_hd__decap_3
X_3011_ VGND VGND VPWR VPWR _1419_ _2114_ _2113_ Nand_gate
X_4060_ VGND VGND VPWR VPWR _1064_ _1070_ _1071_ Nor_gate
XFILLER_0_3_15 VPWR VGND VPWR VGND sky130_ef_sc_hd__decap_12
X_2390_ VGND VGND VPWR VPWR _1490_ _1498_ _1499_ Nor_gate
XFILLER_0_58_175 VGND VGND VPWR VPWR sky130_fd_sc_hd__decap_3
X_3913_ VGND VGND VPWR VPWR _0511_ _0911_ _0912_ Nor_gate
XFILLER_0_58_197 VGND VGND VPWR VPWR sky130_fd_sc_hd__decap_8
X_2726_ VGND VGND VPWR VPWR _1827_ _1833_ _1832_ Nand_gate
X_3775_ VPWR VGND VGND VPWR net49 _0762_ _0761_ Xnor
X_3844_ VGND VGND VPWR VPWR _0727_ _0837_ _0836_ Nand_gate
X_2588_ VGND VGND VPWR VPWR _1587_ _1696_ _1697_ Nor_gate
X_2657_ VGND VGND VPWR VPWR _1701_ _1764_ _1765_ Nor_gate
X_4327_ VGND VGND VPWR VPWR _2147_ net61 _1358_ Nor_gate
XFILLER_0_1_161 VGND VGND VPWR VPWR sky130_fd_sc_hd__fill_2
X_4189_ VGND VGND VPWR VPWR _1570_ _1210_ _1207_ Nand_gate
X_4258_ VGND VGND VPWR VPWR net90 _1283_ inverter
X_3209_ VGND VGND VPWR VPWR _0150_ net2 inverter
XFILLER_0_20_226 VGND VGND VPWR VPWR sky130_fd_sc_hd__decap_4
XFILLER_0_20_259 VGND VGND VPWR VPWR sky130_fd_sc_hd__fill_1
XFILLER_0_18_27 VGND VGND VPWR VPWR sky130_fd_sc_hd__fill_1
XFILLER_0_34_15 VPWR VGND VPWR VGND sky130_ef_sc_hd__decap_12
XFILLER_0_55_178 VGND VGND VPWR VPWR sky130_fd_sc_hd__decap_6
XFILLER_0_55_167 VGND VGND VPWR VPWR sky130_fd_sc_hd__fill_1
X_3560_ VGND VGND VPWR VPWR _0529_ _0530_ _0291_ Nand_gate
X_2511_ VGND VGND VPWR VPWR _1618_ _1620_ _1619_ Nand_gate
X_2442_ VGND VGND VPWR VPWR net17 _1550_ _1551_ Nor_gate
X_3491_ VGND VGND VPWR VPWR _1625_ _0456_ _2106_ Nand_gate
X_2373_ VGND VGND VPWR VPWR _1219_ _1481_ _1482_ Nor_gate
X_4043_ VGND VGND VPWR VPWR _1052_ net18 net17 _1676_ Mux
XFILLER_0_38_7 VGND VGND VPWR VPWR sky130_fd_sc_hd__fill_1
X_4112_ VGND VGND VPWR VPWR _1127_ _1126_ inverter
XFILLER_0_34_307 VGND VGND VPWR VPWR sky130_fd_sc_hd__fill_1
XFILLER_0_19_337 VGND VGND VPWR VPWR sky130_fd_sc_hd__decap_6
X_2709_ VPWR VGND VGND VPWR net23 _1816_ _1815_ Xnor
XFILLER_0_34_329 VGND VGND VPWR VPWR sky130_fd_sc_hd__fill_2
X_3758_ VGND VGND VPWR VPWR _0745_ _1985_ _0513_ _0593_ Mux
X_3689_ VGND VGND VPWR VPWR _0661_ _0670_ _0669_ Nand_gate
XFILLER_0_6_231 VGND VGND VPWR VPWR sky130_fd_sc_hd__decap_6
XFILLER_0_6_253 VPWR VGND VPWR VGND sky130_ef_sc_hd__decap_12
XFILLER_0_6_297 VGND VGND VPWR VPWR sky130_fd_sc_hd__decap_8
X_3827_ VGND VGND VPWR VPWR net49 _0818_ _0215_ Nand_gate
XFILLER_0_10_270 VPWR VGND VPWR VGND sky130_ef_sc_hd__decap_12
XFILLER_0_37_145 VPWR VGND VPWR VGND sky130_ef_sc_hd__decap_12
XFILLER_0_29_48 VGND VGND VPWR VPWR sky130_fd_sc_hd__fill_1
X_2991_ VGND VGND VPWR VPWR _2094_ _2093_ inverter
XFILLER_0_28_123 VGND VGND VPWR VPWR sky130_fd_sc_hd__decap_3
XFILLER_0_0_27 VGND VGND VPWR VPWR sky130_fd_sc_hd__fill_1
XFILLER_0_16_307 VGND VGND VPWR VPWR sky130_fd_sc_hd__fill_1
XFILLER_0_28_178 VGND VGND VPWR VPWR sky130_fd_sc_hd__fill_1
X_3612_ VGND VGND VPWR VPWR _0585_ _0587_ _1984_ Nand_gate
XFILLER_0_3_212 VGND VGND VPWR VPWR sky130_fd_sc_hd__fill_1
X_3543_ _1985_ VGND VGND VPWR VPWR _0512_ sky130_fd_sc_hd__buf_2
X_2356_ VGND VGND VPWR VPWR _1456_ _1464_ _1465_ Nor_gate
X_3474_ VGND VGND VPWR VPWR _0424_ _0340_ _0437_ Nor_gate
X_2425_ VGND VGND VPWR VPWR _1533_ _1534_ net49 Nand_gate
X_4026_ VGND VGND VPWR VPWR net18 _1030_ _1033_ Nor_gate
XFILLER_0_29_3 VPWR VGND VPWR VGND sky130_ef_sc_hd__decap_12
X_2287_ VGND VGND VPWR VPWR _1176_ _1294_ _1284_ Nand_gate
XFILLER_0_34_148 VPWR VGND VPWR VGND sky130_ef_sc_hd__decap_12
XFILLER_0_34_126 VGND VGND VPWR VPWR sky130_fd_sc_hd__decap_4
XFILLER_0_19_167 VGND VGND VPWR VPWR sky130_fd_sc_hd__fill_1
XFILLER_0_42_192 VGND VGND VPWR VPWR sky130_fd_sc_hd__decap_4
XFILLER_0_15_39 VGND VGND VPWR VPWR sky130_fd_sc_hd__decap_3
XFILLER_0_31_27 VGND VGND VPWR VPWR sky130_fd_sc_hd__decap_3
XFILLER_0_25_137 VGND VGND VPWR VPWR sky130_fd_sc_hd__fill_2
X_3190_ VGND VGND VPWR VPWR _0126_ _0129_ _0130_ Nor_gate
X_2210_ VGND VGND VPWR VPWR _0452_ net49 _0463_ Nor_gate
XFILLER_0_56_295 VPWR VGND VPWR VGND sky130_ef_sc_hd__decap_12
X_2974_ VGND VGND VPWR VPWR _1411_ _2025_ _2077_ Nor_gate
XFILLER_0_16_137 VGND VGND VPWR VPWR sky130_fd_sc_hd__decap_3
XFILLER_0_24_170 VPWR VGND VPWR VGND sky130_ef_sc_hd__decap_12
XFILLER_0_21_60 VGND VGND VPWR VPWR sky130_fd_sc_hd__decap_4
X_3526_ VGND VGND VPWR VPWR _1014_ _0493_ _0491_ Nand_gate
X_3388_ VGND VGND VPWR VPWR _0040_ _1698_ _0345_ Nor_gate
X_2339_ VGND VGND VPWR VPWR _1418_ _1448_ _1447_ Nand_gate
X_3457_ VGND VGND VPWR VPWR _1813_ _0417_ _0418_ Nor_gate
X_2408_ VGND VGND VPWR VPWR _1515_ _1516_ _1517_ Nor_gate
X_4009_ VGND VGND VPWR VPWR net17 net53 _1016_ Nor_gate
XFILLER_0_1_81 VPWR VGND VPWR VGND sky130_ef_sc_hd__decap_12
XFILLER_0_15_181 VPWR VGND VPWR VGND sky130_ef_sc_hd__decap_12
XFILLER_0_30_173 VGND VGND VPWR VPWR sky130_fd_sc_hd__decap_6
XFILLER_0_53_210 VGND VGND VPWR VPWR sky130_fd_sc_hd__decap_4
XFILLER_0_42_15 VPWR VGND VPWR VGND sky130_ef_sc_hd__decap_12
XANTENNA_3 _2044_ VGND VGND VPWR VPWR sky130_fd_sc_hd__diode_2
X_2690_ VGND VGND VPWR VPWR _1698_ _1798_ _1797_ Nand_gate
X_4360_ VGND VGND VPWR VPWR _0864_ _1394_ _0919_ Nand_gate
X_3311_ VGND VGND VPWR VPWR _1471_ _0001_ _0261_ Nor_gate
XTAP_379 VGND VPWR sky130_fd_sc_hd__tapvpwrvgnd_1
XTAP_368 VGND VPWR sky130_fd_sc_hd__tapvpwrvgnd_1
XTAP_357 VGND VPWR sky130_fd_sc_hd__tapvpwrvgnd_1
XTAP_346 VGND VPWR sky130_fd_sc_hd__tapvpwrvgnd_1
X_3242_ VGND VGND VPWR VPWR _1726_ _0186_ _1845_ Nand_gate
XTAP_335 VGND VPWR sky130_fd_sc_hd__tapvpwrvgnd_1
XTAP_324 VGND VPWR sky130_fd_sc_hd__tapvpwrvgnd_1
XTAP_313 VGND VPWR sky130_fd_sc_hd__tapvpwrvgnd_1
XTAP_302 VGND VPWR sky130_fd_sc_hd__tapvpwrvgnd_1
X_3173_ VGND VGND VPWR VPWR _0107_ _0111_ _0110_ Nand_gate
X_4291_ VGND VGND VPWR VPWR _0468_ _1320_ _0741_ Nand_gate
XPHY_19 VGND VGND VPWR VPWR sky130_fd_sc_hd__decap_3
XFILLER_0_16_82 VGND VGND VPWR VPWR sky130_fd_sc_hd__fill_2
X_2888_ VGND VGND VPWR VPWR _1605_ _1993_ _1419_ Nand_gate
X_2957_ VGND VGND VPWR VPWR _1410_ _1978_ _2061_ Nor_gate
XFILLER_0_4_9 VPWR VGND VPWR VGND sky130_ef_sc_hd__decap_12
X_3509_ VGND VGND VPWR VPWR _0442_ _0475_ _0476_ Nor_gate
XFILLER_0_12_29 VPWR VGND VPWR VGND sky130_ef_sc_hd__decap_12
XFILLER_0_50_202 VGND VGND VPWR VPWR sky130_fd_sc_hd__fill_2
XFILLER_0_35_243 VGND VGND VPWR VPWR sky130_fd_sc_hd__decap_8
Xoutput95 net95 VGND VGND VPWR VPWR result[4] sky130_fd_sc_hd__clkbuf_4
Xoutput84 net84 VGND VGND VPWR VPWR result[23] sky130_fd_sc_hd__clkbuf_4
Xoutput73 net73 VGND VGND VPWR VPWR result[13] sky130_fd_sc_hd__clkbuf_4
XFILLER_0_41_202 VGND VGND VPWR VPWR sky130_fd_sc_hd__decap_6
X_2742_ VGND VGND VPWR VPWR _1833_ _1849_ _1848_ Nand_gate
X_2811_ VGND VGND VPWR VPWR _1912_ _1916_ _1917_ Nor_gate
X_3791_ VGND VGND VPWR VPWR _0775_ _0779_ _0780_ Nor_gate
X_3860_ VGND VGND VPWR VPWR _1531_ _0001_ _0855_ Nor_gate
XFILLER_0_41_246 VGND VGND VPWR VPWR sky130_fd_sc_hd__decap_8
X_2673_ VGND VGND VPWR VPWR _1586_ _1780_ _1781_ Nor_gate
X_4274_ VGND VGND VPWR VPWR _1298_ _1300_ _1301_ Nor_gate
XFILLER_0_1_332 VGND VGND VPWR VPWR sky130_fd_sc_hd__decap_4
XTAP_121 VGND VPWR sky130_fd_sc_hd__tapvpwrvgnd_1
XTAP_132 VGND VPWR sky130_fd_sc_hd__tapvpwrvgnd_1
X_4343_ VGND VGND VPWR VPWR _0012_ _1375_ _0148_ Nand_gate
X_3087_ VGND VGND VPWR VPWR _1410_ _0018_ _2075_ Nand_gate
XTAP_154 VGND VPWR sky130_fd_sc_hd__tapvpwrvgnd_1
XTAP_143 VGND VPWR sky130_fd_sc_hd__tapvpwrvgnd_1
XTAP_165 VGND VPWR sky130_fd_sc_hd__tapvpwrvgnd_1
X_3225_ VGND VGND VPWR VPWR _0165_ _0166_ _0167_ Nor_gate
XTAP_176 VGND VPWR sky130_fd_sc_hd__tapvpwrvgnd_1
X_3156_ VGND VGND VPWR VPWR _0092_ _0091_ inverter
XTAP_187 VGND VPWR sky130_fd_sc_hd__tapvpwrvgnd_1
XTAP_198 VGND VPWR sky130_fd_sc_hd__tapvpwrvgnd_1
XFILLER_0_49_335 VGND VGND VPWR VPWR sky130_fd_sc_hd__fill_1
XFILLER_0_17_210 VGND VGND VPWR VPWR sky130_fd_sc_hd__fill_1
XFILLER_0_32_257 VGND VGND VPWR VPWR sky130_fd_sc_hd__fill_1
X_3989_ VGND VGND VPWR VPWR _0990_ _0993_ _0994_ Nor_gate
X_3010_ VGND VGND VPWR VPWR _1438_ _2112_ _2113_ Nor_gate
XFILLER_0_3_27 VPWR VGND VPWR VGND sky130_ef_sc_hd__decap_12
XFILLER_0_58_121 VGND VGND VPWR VPWR sky130_fd_sc_hd__decap_8
X_3843_ VGND VGND VPWR VPWR _0836_ _0835_ inverter
X_3912_ VGND VGND VPWR VPWR _0911_ _0512_ _0513_ _0354_ Mux
X_2725_ VGND VGND VPWR VPWR _1636_ _1831_ _1832_ Nor_gate
X_2656_ VGND VGND VPWR VPWR _1764_ _1643_ inverter
X_3774_ VGND VGND VPWR VPWR _0215_ _0761_ _0760_ Nand_gate
X_2587_ VGND VGND VPWR VPWR _1690_ _1695_ _1696_ Nor_gate
X_4257_ VGND VGND VPWR VPWR _1254_ _1282_ _1283_ Nor_gate
X_4326_ VGND VGND VPWR VPWR _0840_ _1356_ _1357_ Nor_gate
X_3208_ VGND VGND VPWR VPWR net100 _0148_ inverter
X_4188_ VGND VGND VPWR VPWR _1570_ _1207_ _1209_ Nor_gate
X_3139_ VGND VGND VPWR VPWR _0071_ _0075_ _0074_ Nand_gate
XFILLER_0_49_154 VGND VGND VPWR VPWR sky130_fd_sc_hd__decap_8
XFILLER_0_49_143 VGND VGND VPWR VPWR sky130_fd_sc_hd__decap_8
XFILLER_0_37_316 VGND VGND VPWR VPWR sky130_fd_sc_hd__fill_1
XFILLER_0_9_284 VGND VGND VPWR VPWR sky130_fd_sc_hd__fill_1
XFILLER_0_20_249 VGND VGND VPWR VPWR sky130_fd_sc_hd__decap_3
XFILLER_0_20_205 VGND VGND VPWR VPWR sky130_fd_sc_hd__decap_3
XFILLER_0_50_15 VPWR VGND VPWR VGND sky130_ef_sc_hd__decap_12
XFILLER_0_34_27 VGND VGND VPWR VPWR sky130_fd_sc_hd__fill_1
X_3490_ VGND VGND VPWR VPWR _1862_ _0454_ _0455_ Nor_gate
X_2510_ VGND VGND VPWR VPWR _1440_ _1590_ _1619_ Nor_gate
X_2441_ VGND VGND VPWR VPWR _1550_ net53 inverter
X_4111_ VGND VGND VPWR VPWR _1120_ _1125_ _1126_ Nor_gate
XFILLER_0_11_249 VGND VGND VPWR VPWR sky130_fd_sc_hd__decap_4
X_2372_ VGND VGND VPWR VPWR _1477_ _1480_ _1481_ Nor_gate
X_4042_ VGND VGND VPWR VPWR _0229_ _1051_ _0628_ Nand_gate
XFILLER_0_46_113 VPWR VGND VPWR VGND sky130_ef_sc_hd__decap_12
XFILLER_0_46_102 VGND VGND VPWR VPWR sky130_fd_sc_hd__fill_2
XFILLER_0_24_71 VGND VGND VPWR VPWR sky130_fd_sc_hd__decap_6
XFILLER_0_24_60 VGND VGND VPWR VPWR sky130_fd_sc_hd__decap_3
X_3826_ VGND VGND VPWR VPWR net81 _0817_ inverter
XFILLER_0_40_92 VGND VGND VPWR VPWR sky130_fd_sc_hd__fill_1
XFILLER_0_40_70 VGND VGND VPWR VPWR sky130_fd_sc_hd__fill_2
X_2639_ VGND VGND VPWR VPWR _1726_ _1747_ _1746_ Nand_gate
X_2708_ VPWR VGND VGND VPWR _1438_ _1815_ _1814_ Xnor
X_3757_ VGND VGND VPWR VPWR _1916_ _0742_ _0743_ Nor_gate
X_3688_ VGND VGND VPWR VPWR _0666_ _0667_ _0669_ Nor_gate
XFILLER_0_6_265 VGND VGND VPWR VPWR sky130_fd_sc_hd__decap_4
X_4309_ VGND VGND VPWR VPWR _1335_ _1339_ _1338_ Nand_gate
XFILLER_0_10_282 VGND VGND VPWR VPWR sky130_fd_sc_hd__fill_2
XFILLER_0_37_113 VGND VGND VPWR VPWR sky130_fd_sc_hd__decap_8
XFILLER_0_37_157 VGND VGND VPWR VPWR sky130_fd_sc_hd__decap_6
XFILLER_0_45_15 VPWR VGND VPWR VGND sky130_ef_sc_hd__decap_12
X_2990_ VGND VGND VPWR VPWR _2093_ _2013_ _2092_ _1432_ Mux
XFILLER_0_16_319 VGND VGND VPWR VPWR sky130_fd_sc_hd__fill_1
X_3611_ VGND VGND VPWR VPWR _0585_ _1684_ _0586_ Nor_gate
X_3473_ VGND VGND VPWR VPWR _0433_ _0436_ _0435_ Nand_gate
XFILLER_0_3_279 VGND VGND VPWR VPWR sky130_fd_sc_hd__fill_1
X_3542_ _1682_ VGND VGND VPWR VPWR _0511_ sky130_fd_sc_hd__clkbuf_4
X_2355_ VGND VGND VPWR VPWR _1457_ _1463_ _1464_ Nor_gate
XFILLER_0_19_60 VGND VGND VPWR VPWR sky130_fd_sc_hd__fill_1
X_2424_ VGND VGND VPWR VPWR _1533_ net13 inverter
X_2286_ VGND VGND VPWR VPWR _1219_ _1273_ _1284_ Nor_gate
XFILLER_0_35_70 VGND VGND VPWR VPWR sky130_fd_sc_hd__fill_1
X_4025_ VGND VGND VPWR VPWR _1548_ _1031_ _1032_ Nor_gate
XFILLER_0_19_113 VGND VGND VPWR VPWR sky130_fd_sc_hd__fill_2
X_3809_ VGND VGND VPWR VPWR _0102_ _0799_ _0800_ Nor_gate
XFILLER_0_34_105 VGND VGND VPWR VPWR sky130_fd_sc_hd__fill_1
XFILLER_0_31_39 VGND VGND VPWR VPWR sky130_fd_sc_hd__fill_2
X_2973_ VGND VGND VPWR VPWR _1410_ _2075_ _2076_ Nor_gate
XFILLER_0_16_116 VGND VGND VPWR VPWR sky130_fd_sc_hd__fill_1
XFILLER_0_24_182 VGND VGND VPWR VPWR sky130_fd_sc_hd__fill_2
XFILLER_0_21_94 VGND VGND VPWR VPWR sky130_fd_sc_hd__fill_2
X_3456_ VGND VGND VPWR VPWR _0282_ _0416_ _0417_ Nor_gate
X_3525_ VGND VGND VPWR VPWR _1014_ _0491_ _0492_ Nor_gate
XFILLER_0_12_300 VGND VGND VPWR VPWR sky130_fd_sc_hd__decap_8
X_2338_ VGND VGND VPWR VPWR _1422_ _1447_ _1446_ Nand_gate
X_4008_ VGND VGND VPWR VPWR _1550_ _0001_ _1015_ Nor_gate
X_2269_ VGND VGND VPWR VPWR net32 _1100_ net68 Nand_gate
X_2407_ VGND VGND VPWR VPWR net9 net45 _1516_ Nor_gate
X_3387_ VGND VGND VPWR VPWR _0340_ _0343_ _0342_ Nand_gate
XFILLER_0_1_93 VPWR VGND VPWR VGND sky130_ef_sc_hd__decap_12
XFILLER_0_15_193 VGND VGND VPWR VPWR sky130_fd_sc_hd__decap_3
XFILLER_0_30_163 VGND VGND VPWR VPWR sky130_fd_sc_hd__decap_6
XFILLER_0_53_200 VGND VGND VPWR VPWR sky130_fd_sc_hd__fill_1
XFILLER_0_42_27 VGND VGND VPWR VPWR sky130_fd_sc_hd__fill_1
X_3310_ VGND VGND VPWR VPWR _1863_ _0260_ _0259_ Nand_gate
XTAP_314 VGND VPWR sky130_fd_sc_hd__tapvpwrvgnd_1
XTAP_303 VGND VPWR sky130_fd_sc_hd__tapvpwrvgnd_1
X_4290_ VGND VGND VPWR VPWR _1562_ _1318_ _1319_ Nor_gate
XFILLER_0_21_130 VPWR VGND VPWR VGND sky130_ef_sc_hd__decap_12
XFILLER_0_6_27 VGND VGND VPWR VPWR sky130_fd_sc_hd__fill_1
XTAP_369 VGND VPWR sky130_fd_sc_hd__tapvpwrvgnd_1
XTAP_358 VGND VPWR sky130_fd_sc_hd__tapvpwrvgnd_1
XTAP_347 VGND VPWR sky130_fd_sc_hd__tapvpwrvgnd_1
XTAP_336 VGND VPWR sky130_fd_sc_hd__tapvpwrvgnd_1
XTAP_325 VGND VPWR sky130_fd_sc_hd__tapvpwrvgnd_1
X_3241_ VGND VGND VPWR VPWR _0175_ _0185_ _0184_ Nand_gate
X_3172_ VGND VGND VPWR VPWR _0108_ _0110_ _0109_ Nand_gate
XFILLER_0_29_241 VGND VGND VPWR VPWR sky130_fd_sc_hd__decap_3
X_2887_ VGND VGND VPWR VPWR _1625_ _1991_ _1992_ Nor_gate
X_2956_ VGND VGND VPWR VPWR net28 _2060_ _1978_ Nand_gate
XFILLER_0_12_130 VGND VGND VPWR VPWR sky130_fd_sc_hd__decap_8
X_3439_ VGND VGND VPWR VPWR _0394_ _0400_ _0399_ Nand_gate
XFILLER_0_12_141 VGND VGND VPWR VPWR sky130_fd_sc_hd__fill_2
XFILLER_0_12_163 VGND VGND VPWR VPWR sky130_fd_sc_hd__decap_4
XFILLER_0_12_174 VPWR VGND VPWR VGND sky130_ef_sc_hd__decap_12
X_3508_ VGND VGND VPWR VPWR _0447_ _0475_ _0473_ Nand_gate
Xoutput96 net96 VGND VGND VPWR VPWR result[5] sky130_fd_sc_hd__buf_2
Xoutput85 net85 VGND VGND VPWR VPWR result[24] sky130_fd_sc_hd__clkbuf_4
Xoutput74 net74 VGND VGND VPWR VPWR result[14] sky130_fd_sc_hd__clkbuf_4
XFILLER_0_58_303 VGND VGND VPWR VPWR sky130_fd_sc_hd__decap_4
XFILLER_0_53_15 VPWR VGND VPWR VGND sky130_ef_sc_hd__decap_12
X_2672_ VPWR VGND VGND VPWR net12 _1780_ _1779_ Xnor
X_2741_ VGND VGND VPWR VPWR _1650_ _1848_ _1847_ Nand_gate
X_2810_ VGND VGND VPWR VPWR _1909_ _1915_ _1916_ Nor_gate
XFILLER_0_26_244 VGND VGND VPWR VPWR sky130_fd_sc_hd__decap_4
XFILLER_0_26_233 VGND VGND VPWR VPWR sky130_fd_sc_hd__fill_2
X_3790_ VGND VGND VPWR VPWR _0718_ _0778_ _0779_ Nor_gate
XFILLER_0_41_269 VGND VGND VPWR VPWR sky130_fd_sc_hd__fill_2
X_4273_ VGND VGND VPWR VPWR _0269_ _1300_ _1299_ Nand_gate
XTAP_144 VGND VPWR sky130_fd_sc_hd__tapvpwrvgnd_1
XTAP_122 VGND VPWR sky130_fd_sc_hd__tapvpwrvgnd_1
XTAP_133 VGND VPWR sky130_fd_sc_hd__tapvpwrvgnd_1
XTAP_155 VGND VPWR sky130_fd_sc_hd__tapvpwrvgnd_1
XTAP_166 VGND VPWR sky130_fd_sc_hd__tapvpwrvgnd_1
X_3224_ VGND VGND VPWR VPWR _0039_ _0166_ _0096_ Nand_gate
X_4342_ VGND VGND VPWR VPWR net74 _1373_ _1374_ Nor_gate
.ends
