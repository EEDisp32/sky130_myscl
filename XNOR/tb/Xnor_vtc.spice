* SkyWater 130nm XNOR Gate VTC (Voltage Transfer Characteristic) Testbench

.lib "/home/onur/.ciel/ciel/sky130/versions/0fe599b2afb6708d281543108caf8310912f54af/sky130A/libs.tech/ngspice/sky130.lib.spice" tt
.include "Xnor.spice"

Vdd VPWR 0 1.8V
Vss VGND 0 0V
Vpb VPB  0 1.8V
Vnb VNB  0 0V

Va A 0 0V
Vb B 0 0V

XXNOR1 VPWR VGND VNB VPB A B Y Xnor

* Sweep source Va from 0V to 1.8V with 0.01V (10mV) steps.
* While doing this, keep source Vb at two different states: 0V and 1.8V (Nested sweep).
.dc Va 0 1.8 0.01 Vb 0 1.8 1.8

.control
  run

  plot v(Y) vs v(A) title "VTC Graph"

  * Gain calculation (Gain = d(Vout)/d(Vin))
  let gain = deriv(v(Y))
  plot gain vs v(A) title "Voltage Gain (dVout / dVin)"

  * V_inv (Threshold Voltage: point where Vin = Vout)
  meas dc V_inv find v(A) when v(A)=v(Y)

  print V_inv
.endc
.end
