* NGSPICE file created from Mux.ext - technology: sky130A

.subckt Mux VGND VNB VPB VPWR Y A B S
X0 a_462_47# B a_76_199# VNB sky130_fd_pr__nfet_01v8 ad=0.0756 pd=0.78 as=0.0567 ps=0.69 w=0.42 l=0.15
X1 a_176_293# S VPWR VPB sky130_fd_pr__pfet_01v8 ad=0.111 pd=1.37 as=0.0567 ps=0.69 w=0.42 l=0.15
X2 VPWR A a_564_374# VPB sky130_fd_pr__pfet_01v8 ad=0.0567 pd=0.69 as=0.0746 ps=0.775 w=0.42 l=0.15
X3 a_76_199# B a_206_374# VPB sky130_fd_pr__pfet_01v8 ad=0.0756 pd=0.78 as=0.237 ps=1.73 w=0.42 l=0.15
X4 a_76_199# a_176_293# a_269_47# VNB sky130_fd_pr__nfet_01v8 ad=0.0567 pd=0.69 as=0.083 ps=0.815 w=0.42 l=0.15
X5 a_564_374# S a_76_199# VPB sky130_fd_pr__pfet_01v8 ad=0.0746 pd=0.775 as=0.0756 ps=0.78 w=0.42 l=0.15
X6 a_269_47# A VGND VNB sky130_fd_pr__nfet_01v8 ad=0.083 pd=0.815 as=0.166 ps=1.3 w=0.42 l=0.15
X7 a_176_293# S VGND VNB sky130_fd_pr__nfet_01v8 ad=0.111 pd=1.37 as=0.163 ps=1.2 w=0.42 l=0.15
X8 VPWR a_76_199# Y VPB sky130_fd_pr__pfet_01v8 ad=0.146 pd=1.34 as=0.26 ps=2.52 w=1 l=0.15
X9 VGND S a_462_47# VNB sky130_fd_pr__nfet_01v8 ad=0.163 pd=1.2 as=0.0756 ps=0.78 w=0.42 l=0.15
X10 a_206_374# a_176_293# VPWR VPB sky130_fd_pr__pfet_01v8 ad=0.237 pd=1.73 as=0.146 ps=1.34 w=0.42 l=0.15
X11 VGND a_76_199# Y VNB sky130_fd_pr__nfet_01v8 ad=0.166 pd=1.3 as=0.169 ps=1.82 w=0.65 l=0.15
C0 A a_206_374# 4.33e-19
C1 a_76_199# a_269_47# 0.00986f
C2 B a_76_199# 0.0323f
C3 VPWR a_269_47# 6.43e-19
C4 VPWR B 0.0108f
C5 VGND A 0.0239f
C6 Y a_176_293# 0.00242f
C7 VPB VGND 0.0128f
C8 a_76_199# a_206_374# 0.0272f
C9 VGND S 0.0848f
C10 VPB A 0.0728f
C11 VPWR a_206_374# 0.00546f
C12 A S 0.166f
C13 VGND a_76_199# 0.203f
C14 VPB S 0.135f
C15 a_176_293# a_564_374# 0.00579f
C16 VGND VPWR 0.0812f
C17 a_176_293# a_462_47# 4.77e-19
C18 A a_76_199# 0.105f
C19 VPB a_76_199# 0.0588f
C20 A VPWR 0.0166f
C21 S a_76_199# 0.00465f
C22 VPB VPWR 0.112f
C23 S VPWR 0.0356f
C24 a_176_293# a_269_47# 1.2e-19
C25 a_176_293# B 0.0966f
C26 Y B 3.67e-21
C27 VPWR a_76_199# 0.255f
C28 a_176_293# a_206_374# 0.00625f
C29 VGND a_176_293# 0.0594f
C30 B a_462_47# 0.00127f
C31 Y VGND 0.0653f
C32 A a_176_293# 0.213f
C33 Y A 3.66e-19
C34 VPB a_176_293# 0.181f
C35 S a_176_293# 0.0777f
C36 Y VPB 0.012f
C37 VGND a_564_374# 0.001f
C38 a_176_293# a_76_199# 0.16f
C39 VGND a_462_47# 0.00572f
C40 Y a_76_199# 0.0693f
C41 a_176_293# VPWR 0.113f
C42 A a_462_47# 0.00192f
C43 Y VPWR 0.128f
C44 VGND a_269_47# 0.00275f
C45 VGND B 0.0218f
C46 a_76_199# a_564_374# 0.0024f
C47 a_76_199# a_462_47# 0.0031f
C48 A a_269_47# 0.00216f
C49 A B 0.0666f
C50 VPWR a_564_374# 0.0061f
C51 VPB B 0.0686f
C52 VPWR a_462_47# 9.65e-19
C53 VGND a_206_374# 0.00201f
C54 S B 0.0966f
.ends
