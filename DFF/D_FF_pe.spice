* NGSPICE file created from D_FF_pe.ext - technology: sky130A

.subckt D_FF_pe CLK VNB VPB VPWR VGND D Q QN
X0 a_617_364# CLKN a_453_47# VPB sky130_fd_pr__pfet_01v8 ad=0.0672 pd=0.85 as=0.214 ps=1.31 w=0.64 l=0.15
X1 a_659_20# a_453_47# VGND VNB sky130_fd_pr__nfet_01v8 ad=0.109 pd=1.36 as=0.0756 ps=0.78 w=0.42 l=0.15
X2 a_984_364# a_659_20# VPWR VPB sky130_fd_pr__pfet_01v8 ad=0.0672 pd=0.85 as=0.166 ps=1.8 w=0.64 l=0.15
X3 VGND a_1262_20# a_1543_297# VNB sky130_fd_pr__nfet_01v8 ad=0.0878 pd=0.92 as=0.169 ps=1.82 w=0.65 l=0.15
X4 VPWR CLK CLKN VPB sky130_fd_pr__pfet_01v8 ad=0.0864 pd=0.91 as=0.166 ps=1.8 w=0.64 l=0.15
X5 a_453_47# a_193_47# a_381_364# VPB sky130_fd_pr__pfet_01v8 ad=0.214 pd=1.31 as=0.0672 ps=0.85 w=0.64 l=0.15
X6 Q a_1543_297# VPWR VPB sky130_fd_pr__pfet_01v8 ad=0.26 pd=2.52 as=0.135 ps=1.27 w=1 l=0.15
X7 VPWR a_1543_297# a_1858_369# VPB sky130_fd_pr__pfet_01v8 ad=0.154 pd=1.34 as=0.166 ps=1.8 w=0.64 l=0.15
X8 a_984_47# a_659_20# VGND VNB sky130_fd_pr__nfet_01v8 ad=0.0441 pd=0.63 as=0.109 ps=1.36 w=0.42 l=0.15
X9 a_1056_47# a_193_47# a_984_47# VNB sky130_fd_pr__nfet_01v8 ad=0.141 pd=1.09 as=0.0441 ps=0.63 w=0.42 l=0.15
X10 VPWR a_1262_20# a_1543_297# VPB sky130_fd_pr__pfet_01v8 ad=0.135 pd=1.27 as=0.27 ps=2.54 w=1 l=0.15
X11 a_1262_20# a_1056_47# VGND VNB sky130_fd_pr__nfet_01v8 ad=0.109 pd=1.36 as=0.0756 ps=0.78 w=0.42 l=0.15
X12 a_381_364# D VPWR VPB sky130_fd_pr__pfet_01v8 ad=0.0672 pd=0.85 as=0.166 ps=1.8 w=0.64 l=0.15
X13 a_1220_47# CLKN a_1056_47# VNB sky130_fd_pr__nfet_01v8 ad=0.0441 pd=0.63 as=0.141 ps=1.09 w=0.42 l=0.15
X14 a_193_47# CLKN VGND VNB sky130_fd_pr__nfet_01v8 ad=0.109 pd=1.36 as=0.0567 ps=0.69 w=0.42 l=0.15
X15 QN a_1858_369# VGND VNB sky130_fd_pr__nfet_01v8 ad=0.169 pd=1.82 as=0.097 ps=0.975 w=0.65 l=0.15
X16 VGND a_1262_20# a_1220_47# VNB sky130_fd_pr__nfet_01v8 ad=0.0756 pd=0.78 as=0.0441 ps=0.63 w=0.42 l=0.15
X17 VPWR a_1262_20# a_1220_364# VPB sky130_fd_pr__pfet_01v8 ad=0.115 pd=1 as=0.0672 ps=0.85 w=0.64 l=0.15
X18 a_193_47# CLKN VPWR VPB sky130_fd_pr__pfet_01v8 ad=0.166 pd=1.8 as=0.0864 ps=0.91 w=0.64 l=0.15
X19 a_1262_20# a_1056_47# VPWR VPB sky130_fd_pr__pfet_01v8 ad=0.166 pd=1.8 as=0.115 ps=1 w=0.64 l=0.15
X20 a_617_47# a_193_47# a_453_47# VNB sky130_fd_pr__nfet_01v8 ad=0.0441 pd=0.63 as=0.141 ps=1.09 w=0.42 l=0.15
X21 a_1220_364# a_193_47# a_1056_47# VPB sky130_fd_pr__pfet_01v8 ad=0.0672 pd=0.85 as=0.214 ps=1.31 w=0.64 l=0.15
X22 QN a_1858_369# VPWR VPB sky130_fd_pr__pfet_01v8 ad=0.26 pd=2.52 as=0.154 ps=1.34 w=1 l=0.15
X23 VGND a_659_20# a_617_47# VNB sky130_fd_pr__nfet_01v8 ad=0.0756 pd=0.78 as=0.0441 ps=0.63 w=0.42 l=0.15
X24 VPWR a_659_20# a_617_364# VPB sky130_fd_pr__pfet_01v8 ad=0.115 pd=1 as=0.0672 ps=0.85 w=0.64 l=0.15
X25 a_659_20# a_453_47# VPWR VPB sky130_fd_pr__pfet_01v8 ad=0.166 pd=1.8 as=0.115 ps=1 w=0.64 l=0.15
X26 a_381_47# D VGND VNB sky130_fd_pr__nfet_01v8 ad=0.0441 pd=0.63 as=0.109 ps=1.36 w=0.42 l=0.15
X27 Q a_1543_297# VGND VNB sky130_fd_pr__nfet_01v8 ad=0.169 pd=1.82 as=0.0878 ps=0.92 w=0.65 l=0.15
X28 VGND a_1543_297# a_1858_369# VNB sky130_fd_pr__nfet_01v8 ad=0.097 pd=0.975 as=0.109 ps=1.36 w=0.42 l=0.15
X29 a_1056_47# CLKN a_984_364# VPB sky130_fd_pr__pfet_01v8 ad=0.214 pd=1.31 as=0.0672 ps=0.85 w=0.64 l=0.15
X30 VGND CLK CLKN VNB sky130_fd_pr__nfet_01v8 ad=0.0567 pd=0.69 as=0.109 ps=1.36 w=0.42 l=0.15
X31 a_453_47# CLKN a_381_47# VNB sky130_fd_pr__nfet_01v8 ad=0.141 pd=1.09 as=0.0441 ps=0.63 w=0.42 l=0.15
C0 CLKN a_453_47# 0.184f
C1 D a_659_20# 0.00242f
C2 a_984_364# VPWR 0.0071f
C3 a_1262_20# a_1543_297# 0.242f
C4 VPB CLKN 0.218f
C5 VGND a_659_20# 0.179f
C6 a_381_47# a_453_47# 0.00228f
C7 a_1262_20# VPWR 0.104f
C8 CLKN a_1220_47# 8.03e-19
C9 QN CLKN 1.43e-19
C10 a_1262_20# Q 0.00215f
C11 a_1056_47# a_1858_369# 1.7e-19
C12 a_193_47# a_659_20# 0.251f
C13 VPB a_1858_369# 0.051f
C14 a_617_47# VGND 0.005f
C15 CLK VPB 0.0701f
C16 QN a_1858_369# 0.0692f
C17 a_984_47# VGND 0.00532f
C18 a_984_364# a_659_20# 0.00135f
C19 a_617_47# a_193_47# 0.00266f
C20 a_617_364# CLKN 1.28e-19
C21 a_1262_20# a_659_20# 0.00242f
C22 VPB a_1056_47# 0.0946f
C23 a_1220_364# VGND 3.22e-19
C24 a_984_47# a_193_47# 0.00258f
C25 a_381_364# CLKN 5.77e-20
C26 D CLKN 0.126f
C27 a_1056_47# a_1220_47# 0.00261f
C28 a_1056_47# QN 1.24e-21
C29 VPB a_453_47# 0.0903f
C30 VGND CLKN 0.178f
C31 a_1220_364# a_193_47# 0.00102f
C32 a_1543_297# VPWR 0.181f
C33 a_381_47# VGND 0.00346f
C34 VPB QN 0.0118f
C35 Q a_1543_297# 0.115f
C36 a_193_47# CLKN 1.16f
C37 Q VPWR 0.116f
C38 a_381_47# a_193_47# 0.00243f
C39 VGND a_1858_369# 0.0917f
C40 CLK VGND 0.0195f
C41 a_1220_364# a_1262_20# 4.91e-19
C42 a_984_364# CLKN 1.28e-19
C43 a_193_47# a_1858_369# 5.24e-19
C44 a_617_364# a_453_47# 0.00711f
C45 CLK a_193_47# 0.00206f
C46 a_1262_20# CLKN 0.0798f
C47 a_381_364# a_453_47# 0.0031f
C48 a_1056_47# VGND 0.103f
C49 a_1543_297# a_659_20# 1.3e-21
C50 D a_453_47# 0.00839f
C51 a_659_20# VPWR 0.124f
C52 VGND a_453_47# 0.088f
C53 D VPB 0.0543f
C54 a_193_47# a_1056_47# 0.185f
C55 VPB VGND 0.0225f
C56 a_193_47# a_453_47# 0.207f
C57 VGND a_1220_47# 0.00384f
C58 VGND QN 0.065f
C59 a_193_47# VPB 0.164f
C60 a_193_47# a_1220_47# 6.92e-19
C61 a_193_47# QN 2.46e-19
C62 a_984_364# a_1056_47# 0.0031f
C63 a_984_47# VPWR 3.07e-19
C64 a_1262_20# a_1056_47# 0.267f
C65 a_1220_364# VPWR 0.00388f
C66 a_617_364# VGND 4.7e-20
C67 a_1262_20# VPB 0.122f
C68 a_1543_297# CLKN 0.00197f
C69 a_381_364# VGND 2.63e-19
C70 CLKN VPWR 0.148f
C71 a_1262_20# a_1220_47# 3.9e-19
C72 D VGND 0.0357f
C73 Q CLKN 4.52e-19
C74 a_617_364# a_193_47# 0.00192f
C75 a_617_47# a_659_20# 3.9e-19
C76 a_381_47# VPWR 1.53e-19
C77 a_381_364# a_193_47# 0.00405f
C78 D a_193_47# 0.0977f
C79 a_984_47# a_659_20# 3.69e-19
C80 a_1543_297# a_1858_369# 0.109f
C81 a_193_47# VGND 0.529f
C82 a_1858_369# VPWR 0.165f
C83 Q a_1858_369# 0.122f
C84 CLK VPWR 0.0194f
C85 a_659_20# CLKN 0.18f
C86 a_1543_297# a_1056_47# 0.00556f
C87 a_984_364# VGND 5.26e-19
C88 a_1056_47# VPWR 0.159f
C89 a_1543_297# a_453_47# 1.82e-21
C90 Q a_1056_47# 5.84e-19
C91 a_1262_20# VGND 0.153f
C92 VPWR a_453_47# 0.146f
C93 a_1543_297# VPB 0.153f
C94 a_984_364# a_193_47# 0.003f
C95 VPB VPWR 0.249f
C96 a_1543_297# QN 0.00403f
C97 a_1262_20# a_193_47# 0.0534f
C98 Q VPB 0.0181f
C99 a_617_47# CLKN 1.26e-19
C100 VPWR a_1220_47# 2.68e-19
C101 QN VPWR 0.128f
C102 a_984_47# CLKN 1.26e-19
C103 a_1056_47# a_659_20# 0.026f
C104 a_659_20# a_453_47# 0.266f
C105 VPB a_659_20# 0.123f
C106 a_617_364# VPWR 0.00562f
C107 a_381_47# CLKN 4.39e-19
C108 a_381_364# VPWR 0.00468f
C109 a_1543_297# VGND 0.134f
C110 D VPWR 0.024f
C111 a_984_47# a_1056_47# 0.00228f
C112 VGND VPWR 0.11f
C113 a_617_47# a_453_47# 0.00261f
C114 a_1858_369# CLKN 5.58e-19
C115 Q VGND 0.0987f
C116 a_1543_297# a_193_47# 0.0019f
C117 CLK CLKN 0.219f
C118 a_1220_364# a_1056_47# 0.00708f
C119 a_193_47# VPWR 0.436f
C120 Q a_193_47# 7.06e-19
C121 a_617_364# a_659_20# 4.91e-19
C122 a_1056_47# CLKN 0.116f
.ends
